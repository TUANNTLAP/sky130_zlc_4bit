* NGSPICE file created from zlc_4bit.ext - technology: sky130A

.subckt zlc_4bit A[3] A[0] A[1] A[2] VDD GND Z[0] Z[2] Z[1]
X0 a_147_345# A[0].t5 Z[2].t4 VDD.t21 sky130_fd_pr__pfet_01v8_hvt ad=0.13 pd=1.26 as=0.26 ps=2.52 w=1 l=0.15
X1 a_1293_123# x2.Y VDD.t3 VDD.t2 sky130_fd_pr__pfet_01v8_hvt ad=0.0567 pd=0.69 as=0.1176 ps=1.4 w=0.42 l=0.15
X2 GND.t32 A[3].t2 x2.Y GND.t31 sky130_fd_pr__nfet_01v8 ad=0.169 pd=1.82 as=0.08775 ps=0.92 w=0.65 l=0.15
X3 x8.X a_2774_345# VDD.t7 VDD.t6 sky130_fd_pr__pfet_01v8_hvt ad=0.34 pd=2.68 as=0.14575 ps=1.335 w=1 l=0.15
X4 Z[1].t1 a_1293_123# VDD.t1 VDD.t0 sky130_fd_pr__pfet_01v8_hvt ad=0.475 pd=2.95 as=0.16655 ps=1.39 w=1 l=0.15
X5 GND.t30 x8.X a_3311_123# GND.t29 sky130_fd_pr__nfet_01v8 ad=0.1118 pd=1.04 as=0.0567 ps=0.69 w=0.42 l=0.15
X6 VDD.t32 A[3].t4 a_607_345# VDD.t31 sky130_fd_pr__pfet_01v8_hvt ad=0.26 pd=2.52 as=0.105 ps=1.21 w=1 l=0.15
X7 GND.t38 A[1].t2 a_842_345# GND.t37 sky130_fd_pr__nfet_01v8 ad=0.10025 pd=0.985 as=0.0567 ps=0.69 w=0.42 l=0.15
X8 x7.X a_2305_123# GND.t8 GND.t7 sky130_fd_pr__nfet_01v8 ad=0.182 pd=1.86 as=0.1118 ps=1.04 w=0.65 l=0.15
X9 VDD.t39 A[1].t4 a_924_345# VDD.t38 sky130_fd_pr__pfet_01v8_hvt ad=0.14575 pd=1.335 as=0.0441 ps=0.63 w=0.42 l=0.15
X10 a_3311_123# x5.Y a_3225_123# GND.t11 sky130_fd_pr__nfet_01v8 ad=0.0567 pd=0.69 as=0.1176 ps=1.4 w=0.42 l=0.15
X11 x6.Y A[1].t0 GND.t40 GND.t39 sky130_fd_pr__nfet_01v8 ad=0.169 pd=1.82 as=0.169 ps=1.82 w=0.65 l=0.15
X12 Z[2].t3 A[0].t3 GND.t26 GND.t25 sky130_fd_pr__nfet_01v8 ad=0.11863 pd=1.015 as=0.169 ps=1.82 w=0.65 l=0.15
X13 a_607_345# A[2].t4 x2.Y VDD.t19 sky130_fd_pr__pfet_01v8_hvt ad=0.105 pd=1.21 as=0.26 ps=2.52 w=1 l=0.15
X14 x2.Y A[2].t2 GND.t20 GND.t19 sky130_fd_pr__nfet_01v8 ad=0.08775 pd=0.92 as=0.169 ps=1.82 w=0.65 l=0.15
X15 a_335_345# A[2].t5 a_229_345# VDD.t18 sky130_fd_pr__pfet_01v8_hvt ad=0.135 pd=1.27 as=0.19 ps=1.38 w=1 l=0.15
X16 Z[1].t0 a_1293_123# GND.t1 GND.t0 sky130_fd_pr__nfet_01v8 ad=0.182 pd=1.86 as=0.1118 ps=1.04 w=0.65 l=0.15
X17 a_229_345# A[1].t5 a_147_345# VDD.t35 sky130_fd_pr__pfet_01v8_hvt ad=0.19 pd=1.38 as=0.13 ps=1.26 w=1 l=0.15
X18 a_924_345# A[0].t4 a_842_345# VDD.t22 sky130_fd_pr__pfet_01v8_hvt ad=0.0441 pd=0.63 as=0.1092 ps=1.36 w=0.42 l=0.15
X19 a_2856_345# A[2].t1 a_2774_345# VDD.t20 sky130_fd_pr__pfet_01v8_hvt ad=0.0441 pd=0.63 as=0.1092 ps=1.36 w=0.42 l=0.15
X20 VDD.t28 x8.X a_3225_123# VDD.t27 sky130_fd_pr__pfet_01v8_hvt ad=0.16655 pd=1.39 as=0.0567 ps=0.69 w=0.42 l=0.15
X21 x3.X a_842_345# VDD.t15 VDD.t14 sky130_fd_pr__pfet_01v8_hvt ad=0.34 pd=2.68 as=0.14575 ps=1.335 w=1 l=0.15
X22 GND.t42 A[1].t3 Z[2].t0 GND.t41 sky130_fd_pr__nfet_01v8 ad=0.08937 pd=0.925 as=0.11863 ps=1.015 w=0.65 l=0.15
X23 a_3225_123# x5.Y VDD.t13 VDD.t12 sky130_fd_pr__pfet_01v8_hvt ad=0.0567 pd=0.69 as=0.1176 ps=1.4 w=0.42 l=0.15
X24 Z[0].t0 a_3225_123# GND.t4 GND.t3 sky130_fd_pr__nfet_01v8 ad=0.182 pd=1.86 as=0.1118 ps=1.04 w=0.65 l=0.15
X25 Z[0].t1 a_3225_123# VDD.t5 VDD.t4 sky130_fd_pr__pfet_01v8_hvt ad=0.475 pd=2.95 as=0.16655 ps=1.39 w=1 l=0.15
X26 x5.Y A[3].t1 VDD.t34 VDD.t33 sky130_fd_pr__pfet_01v8_hvt ad=0.26 pd=2.52 as=0.26 ps=2.52 w=1 l=0.15
X27 GND.t24 A[0].t0 a_2391_123# GND.t23 sky130_fd_pr__nfet_01v8 ad=0.1118 pd=1.04 as=0.0567 ps=0.69 w=0.42 l=0.15
X28 a_2774_345# A[2].t0 GND.t16 GND.t15 sky130_fd_pr__nfet_01v8 ad=0.0567 pd=0.69 as=0.1092 ps=1.36 w=0.42 l=0.15
X29 Z[2].t1 A[2].t3 GND.t18 GND.t17 sky130_fd_pr__nfet_01v8 ad=0.08775 pd=0.92 as=0.08937 ps=0.925 w=0.65 l=0.15
X30 a_2391_123# x6.Y a_2305_123# GND.t14 sky130_fd_pr__nfet_01v8 ad=0.0567 pd=0.69 as=0.1176 ps=1.4 w=0.42 l=0.15
X31 GND.t28 x3.X a_1379_123# GND.t27 sky130_fd_pr__nfet_01v8 ad=0.1118 pd=1.04 as=0.0567 ps=0.69 w=0.42 l=0.15
X32 x8.X a_2774_345# GND.t6 GND.t5 sky130_fd_pr__nfet_01v8 ad=0.169 pd=1.82 as=0.10025 ps=0.985 w=0.65 l=0.15
X33 a_1379_123# x2.Y a_1293_123# GND.t2 sky130_fd_pr__nfet_01v8 ad=0.0567 pd=0.69 as=0.1176 ps=1.4 w=0.42 l=0.15
X34 VDD.t24 A[0].t1 a_2305_123# VDD.t23 sky130_fd_pr__pfet_01v8_hvt ad=0.16655 pd=1.39 as=0.0567 ps=0.69 w=0.42 l=0.15
X35 a_842_345# A[0].t2 GND.t22 GND.t21 sky130_fd_pr__nfet_01v8 ad=0.0567 pd=0.69 as=0.1092 ps=1.36 w=0.42 l=0.15
X36 x3.X a_842_345# GND.t13 GND.t12 sky130_fd_pr__nfet_01v8 ad=0.169 pd=1.82 as=0.10025 ps=0.985 w=0.65 l=0.15
X37 x6.Y A[1].t1 VDD.t37 VDD.t36 sky130_fd_pr__pfet_01v8_hvt ad=0.26 pd=2.52 as=0.26 ps=2.52 w=1 l=0.15
X38 GND.t10 x7.X a_2774_345# GND.t9 sky130_fd_pr__nfet_01v8 ad=0.10025 pd=0.985 as=0.0567 ps=0.69 w=0.42 l=0.15
X39 GND.t36 A[3].t3 Z[2].t2 GND.t35 sky130_fd_pr__nfet_01v8 ad=0.169 pd=1.82 as=0.08775 ps=0.92 w=0.65 l=0.15
X40 a_2305_123# x6.Y VDD.t17 VDD.t16 sky130_fd_pr__pfet_01v8_hvt ad=0.0567 pd=0.69 as=0.1176 ps=1.4 w=0.42 l=0.15
X41 x5.Y A[3].t0 GND.t34 GND.t33 sky130_fd_pr__nfet_01v8 ad=0.169 pd=1.82 as=0.169 ps=1.82 w=0.65 l=0.15
X42 VDD.t11 x7.X a_2856_345# VDD.t10 sky130_fd_pr__pfet_01v8_hvt ad=0.14575 pd=1.335 as=0.0441 ps=0.63 w=0.42 l=0.15
X43 x7.X a_2305_123# VDD.t9 VDD.t8 sky130_fd_pr__pfet_01v8_hvt ad=0.475 pd=2.95 as=0.16655 ps=1.39 w=1 l=0.15
X44 VDD.t26 x3.X a_1293_123# VDD.t25 sky130_fd_pr__pfet_01v8_hvt ad=0.16655 pd=1.39 as=0.0567 ps=0.69 w=0.42 l=0.15
X45 VDD.t30 A[3].t5 a_335_345# VDD.t29 sky130_fd_pr__pfet_01v8_hvt ad=0.26 pd=2.52 as=0.135 ps=1.27 w=1 l=0.15
R0 Z[0].n0 Z[0] 590.984
R1 Z[0].n1 Z[0].n0 585
R2 Z[0] Z[0].t0 269.426
R3 Z[0].n0 Z[0].t1 46.2955
R4 Z[0].n3 Z[0] 13.3125
R5 Z[0] Z[0].n4 11.2645
R6 Z[0].n3 Z[0] 9.80131
R7 Z[0] Z[0].n2 6.6565
R8 Z[0].n4 Z[0] 6.1445
R9 Z[0].n4 Z[0] 4.63498
R10 Z[0] Z[0].n3 4.0965
R11 Z[0].n2 Z[0] 3.61789
R12 Z[0].n1 Z[0] 3.47876
R13 Z[0].n2 Z[0].n1 2.36572
R14 Z[1].n3 Z[1].n0 590.149
R15 Z[1].n4 Z[1].n3 585
R16 Z[1] Z[1].t0 269.426
R17 Z[1].n3 Z[1].t1 46.2955
R18 Z[1].n0 Z[1] 21.8585
R19 Z[1] Z[1].n1 11.2645
R20 Z[1].n2 Z[1] 6.6565
R21 Z[1].n1 Z[1] 6.1445
R22 Z[1].n1 Z[1] 4.63498
R23 Z[1].n2 Z[1] 3.61789
R24 Z[1] Z[1].n4 3.47876
R25 Z[1].n4 Z[1].n2 2.36572
R26 Z[1] Z[1].n0 0.835283
R27 Z[2].n4 Z[2].n0 590.159
R28 Z[2].n5 Z[2].n4 289.288
R29 Z[2].n3 Z[2].n2 259.729
R30 Z[2].n3 Z[2].n1 189.589
R31 Z[2].n5 Z[2].n3 81.9525
R32 Z[2].n1 Z[2].t3 42.462
R33 Z[2].n4 Z[2].t4 26.5955
R34 Z[2].n2 Z[2].t2 24.9236
R35 Z[2].n2 Z[2].t1 24.9236
R36 Z[2].n1 Z[2].t0 24.9236
R37 Z[2].n0 Z[2] 14.3445
R38 Z[2] Z[2].n5 11.2013
R39 Z[2] Z[2].n0 3.05722
R40 A[3].n1 A[3].t4 231.835
R41 A[3].n0 A[3].t1 230.576
R42 A[3].n3 A[3].t5 230.155
R43 A[3].n4 A[3].n3 167.508
R44 A[3].n0 A[3].t0 158.275
R45 A[3].n3 A[3].t3 157.856
R46 A[3].n1 A[3].t2 157.07
R47 A[3].n6 A[3].n0 155.733
R48 A[3].n2 A[3].n1 152
R49 A[3].n6 A[3].n5 15.7314
R50 A[3].n5 A[3].n2 11.6337
R51 A[3].n5 A[3].n4 9.3005
R52 A[3].n4 A[3] 3.93896
R53 A[3] A[3].n6 2.93383
R54 A[3].n5 A[3] 2.02478
R55 A[3].n2 A[3] 2.01193
R56 A[2].n1 A[2].t5 241.536
R57 A[2].n0 A[2].t4 230.363
R58 A[2].n3 A[2].t0 192.639
R59 A[2] A[2].n1 188.722
R60 A[2].n1 A[2].t3 169.237
R61 A[2].n0 A[2].t2 158.064
R62 A[2].n4 A[2].n3 154.058
R63 A[2].n6 A[2].n0 153.792
R64 A[2].n3 A[2].t1 134.799
R65 A[2].n5 A[2].n4 26.9626
R66 A[2].n2 A[2] 14.1005
R67 A[2].n6 A[2].n5 10.2939
R68 A[2] A[2].n6 4.6085
R69 A[2].n4 A[2] 4.11479
R70 A[2].n2 A[2] 1.66214
R71 A[2].n5 A[2].n2 0.00233824
R72 A[1].n1 A[1].t5 241.536
R73 A[1].n0 A[1].t1 230.576
R74 A[1].n3 A[1].t2 206.19
R75 A[1].n1 A[1].t3 169.237
R76 A[1] A[1].n1 167.065
R77 A[1].n0 A[1].t0 158.275
R78 A[1].n6 A[1].n0 155.201
R79 A[1].n4 A[1].n3 152
R80 A[1].n3 A[1].t4 148.35
R81 A[1].n6 A[1].n5 17.349
R82 A[1].n5 A[1].n4 14.9456
R83 A[1].n2 A[1] 11.6278
R84 A[1].n5 A[1].n2 6.9196
R85 A[1] A[1].n6 3.46717
R86 A[1].n2 A[1] 1.27863
R87 A[1].n4 A[1] 0.686214
R88 A[0].n0 A[0].t1 261.887
R89 A[0].n3 A[0].t5 230.155
R90 A[0].n1 A[0].t2 192.639
R91 A[0].n3 A[0].t3 157.856
R92 A[0].n0 A[0].t0 155.847
R93 A[0].n2 A[0].n1 153.601
R94 A[0].n7 A[0].n0 152.768
R95 A[0].n4 A[0].n3 152
R96 A[0].n1 A[0].t4 134.799
R97 A[0].n7 A[0].n6 23.7395
R98 A[0].n6 A[0].n2 16.2762
R99 A[0].n5 A[0].n4 10.5872
R100 A[0].n2 A[0] 4.57193
R101 A[0].n6 A[0].n5 4.53091
R102 A[0] A[0].n7 4.0965
R103 A[0].n4 A[0] 2.8165
R104 A[0].n5 A[0] 0.497524
R105 VDD.n0 VDD.t4 757.668
R106 VDD.n38 VDD.t3 675.293
R107 VDD.n8 VDD.t17 675.293
R108 VDD.n3 VDD.t13 675.293
R109 VDD VDD.t6 547.509
R110 VDD VDD.t14 547.509
R111 VDD VDD.t36 503.115
R112 VDD VDD.t33 503.115
R113 VDD VDD.t8 494.238
R114 VDD VDD.t0 494.238
R115 VDD VDD.t31 411.372
R116 VDD VDD.t29 366.978
R117 VDD.n21 VDD.t30 341.928
R118 VDD.n16 VDD.n15 325.627
R119 VDD.n61 VDD.n60 325.627
R120 VDD.n80 VDD.n79 325.627
R121 VDD.t4 VDD.t27 319.627
R122 VDD.t8 VDD.t23 319.627
R123 VDD.t0 VDD.t25 319.627
R124 VDD.n32 VDD.n31 315.303
R125 VDD.n69 VDD.n68 315.303
R126 VDD.t20 VDD 313.707
R127 VDD.t36 VDD 313.707
R128 VDD.t33 VDD 313.707
R129 VDD.t22 VDD 313.707
R130 VDD.t18 VDD.t35 313.707
R131 VDD.t12 VDD 298.911
R132 VDD.t16 VDD 298.911
R133 VDD.t2 VDD 298.911
R134 VDD.t6 VDD.t10 287.072
R135 VDD.t14 VDD.t38 287.072
R136 VDD.n12 VDD.t34 255.905
R137 VDD.n10 VDD.t37 255.905
R138 VDD.t27 VDD.t12 248.599
R139 VDD.t23 VDD.t16 248.599
R140 VDD.t25 VDD.t2 248.599
R141 VDD.t29 VDD.t18 248.599
R142 VDD.n26 VDD.t32 243.512
R143 VDD.t35 VDD.t21 242.679
R144 VDD.t10 VDD.t20 213.084
R145 VDD.t38 VDD.t22 213.084
R146 VDD.t31 VDD.t19 213.084
R147 VDD.t21 VDD 192.369
R148 VDD.t19 VDD 189.409
R149 VDD.n15 VDD.t26 116.341
R150 VDD.n60 VDD.t24 116.341
R151 VDD.n79 VDD.t28 116.341
R152 VDD.n31 VDD.t39 96.1553
R153 VDD.n68 VDD.t11 96.1553
R154 VDD.n25 VDD.n24 34.6358
R155 VDD.n30 VDD.n19 34.6358
R156 VDD.n37 VDD.n17 34.6358
R157 VDD.n33 VDD.n17 34.6358
R158 VDD.n40 VDD.n39 34.6358
R159 VDD.n45 VDD.n44 34.6358
R160 VDD.n44 VDD.n13 34.6358
R161 VDD.n50 VDD.n49 34.6358
R162 VDD.n49 VDD.n11 34.6358
R163 VDD.n55 VDD.n54 34.6358
R164 VDD.n54 VDD.n9 34.6358
R165 VDD.n59 VDD.n58 34.6358
R166 VDD.n67 VDD.n66 34.6358
R167 VDD.n66 VDD.n6 34.6358
R168 VDD.n62 VDD.n6 34.6358
R169 VDD.n74 VDD.n73 34.6358
R170 VDD.n73 VDD.n4 34.6358
R171 VDD.n78 VDD.n2 34.6358
R172 VDD.n82 VDD.n81 34.6358
R173 VDD.n32 VDD.n30 34.2593
R174 VDD.n69 VDD.n67 34.2593
R175 VDD.n15 VDD.t1 28.4453
R176 VDD.n60 VDD.t9 28.4453
R177 VDD.n79 VDD.t5 28.4453
R178 VDD.n31 VDD.t15 25.6105
R179 VDD.n68 VDD.t7 25.6105
R180 VDD.n26 VDD.n19 24.4711
R181 VDD.n24 VDD.n21 23.7181
R182 VDD.n82 VDD.n0 23.7181
R183 VDD.n26 VDD.n25 19.9534
R184 VDD.n12 VDD.n11 10.5417
R185 VDD.n10 VDD.n9 10.5417
R186 VDD.n33 VDD.n32 10.1652
R187 VDD.n69 VDD.n4 10.1652
R188 VDD.n39 VDD.n38 9.41227
R189 VDD.n58 VDD.n8 9.41227
R190 VDD.n3 VDD.n2 9.41227
R191 VDD VDD.n0 9.3031
R192 VDD.n83 VDD.n82 9.3005
R193 VDD.n81 VDD.n1 9.3005
R194 VDD.n78 VDD.n77 9.3005
R195 VDD.n76 VDD.n2 9.3005
R196 VDD.n75 VDD.n74 9.3005
R197 VDD.n73 VDD.n72 9.3005
R198 VDD.n71 VDD.n4 9.3005
R199 VDD.n70 VDD.n69 9.3005
R200 VDD.n67 VDD.n5 9.3005
R201 VDD.n66 VDD.n65 9.3005
R202 VDD.n64 VDD.n6 9.3005
R203 VDD.n63 VDD.n62 9.3005
R204 VDD.n59 VDD.n7 9.3005
R205 VDD.n58 VDD.n57 9.3005
R206 VDD.n56 VDD.n55 9.3005
R207 VDD.n54 VDD.n53 9.3005
R208 VDD.n52 VDD.n9 9.3005
R209 VDD.n51 VDD.n50 9.3005
R210 VDD.n49 VDD.n48 9.3005
R211 VDD.n47 VDD.n11 9.3005
R212 VDD.n46 VDD.n45 9.3005
R213 VDD.n44 VDD.n43 9.3005
R214 VDD.n42 VDD.n13 9.3005
R215 VDD.n41 VDD.n40 9.3005
R216 VDD.n39 VDD.n14 9.3005
R217 VDD.n37 VDD.n36 9.3005
R218 VDD.n35 VDD.n17 9.3005
R219 VDD.n34 VDD.n33 9.3005
R220 VDD.n32 VDD.n18 9.3005
R221 VDD.n30 VDD.n29 9.3005
R222 VDD.n28 VDD.n19 9.3005
R223 VDD.n27 VDD.n26 9.3005
R224 VDD.n25 VDD.n20 9.3005
R225 VDD.n24 VDD.n23 9.3005
R226 VDD.n45 VDD.n12 8.28285
R227 VDD.n50 VDD.n10 8.28285
R228 VDD.n22 VDD.n21 7.25905
R229 VDD.n40 VDD.n16 6.4005
R230 VDD.n61 VDD.n59 6.4005
R231 VDD.n80 VDD.n78 6.4005
R232 VDD.n38 VDD.n37 4.14168
R233 VDD.n55 VDD.n8 4.14168
R234 VDD.n74 VDD.n3 4.14168
R235 VDD.n16 VDD.n13 3.38874
R236 VDD.n62 VDD.n61 3.38874
R237 VDD.n81 VDD.n80 3.38874
R238 VDD.n22 VDD 0.47207
R239 VDD.n83 VDD.n1 0.120292
R240 VDD.n77 VDD.n1 0.120292
R241 VDD.n77 VDD.n76 0.120292
R242 VDD.n76 VDD.n75 0.120292
R243 VDD.n72 VDD.n71 0.120292
R244 VDD.n71 VDD.n70 0.120292
R245 VDD.n70 VDD.n5 0.120292
R246 VDD.n65 VDD.n5 0.120292
R247 VDD.n64 VDD.n63 0.120292
R248 VDD.n63 VDD.n7 0.120292
R249 VDD.n57 VDD.n7 0.120292
R250 VDD.n57 VDD.n56 0.120292
R251 VDD.n53 VDD.n52 0.120292
R252 VDD.n52 VDD.n51 0.120292
R253 VDD.n48 VDD.n47 0.120292
R254 VDD.n47 VDD.n46 0.120292
R255 VDD.n43 VDD.n42 0.120292
R256 VDD.n42 VDD.n41 0.120292
R257 VDD.n41 VDD.n14 0.120292
R258 VDD.n36 VDD.n14 0.120292
R259 VDD.n35 VDD.n34 0.120292
R260 VDD.n34 VDD.n18 0.120292
R261 VDD.n29 VDD.n18 0.120292
R262 VDD.n29 VDD.n28 0.120292
R263 VDD.n27 VDD.n20 0.120292
R264 VDD.n23 VDD.n20 0.120292
R265 VDD VDD.n22 0.0925638
R266 VDD VDD.n83 0.0603958
R267 VDD.n72 VDD 0.0603958
R268 VDD VDD.n64 0.0603958
R269 VDD.n53 VDD 0.0603958
R270 VDD.n48 VDD 0.0603958
R271 VDD.n43 VDD 0.0603958
R272 VDD VDD.n35 0.0603958
R273 VDD VDD.n27 0.0603958
R274 VDD.n75 VDD 0.0226354
R275 VDD.n65 VDD 0.0226354
R276 VDD.n56 VDD 0.0226354
R277 VDD.n51 VDD 0.0226354
R278 VDD.n46 VDD 0.0226354
R279 VDD.n36 VDD 0.0226354
R280 VDD.n28 VDD 0.0226354
R281 VDD.n23 VDD 0.0213333
R282 GND.n0 GND.t3 3818.31
R283 GND GND.t5 2634.3
R284 GND GND.t12 2634.3
R285 GND GND.t39 2420.71
R286 GND GND.t33 2420.71
R287 GND GND.t7 2377.99
R288 GND GND.t0 2377.99
R289 GND GND.t31 1808.41
R290 GND GND.t35 1765.7
R291 GND.t3 GND.t29 1537.86
R292 GND.t7 GND.t23 1537.86
R293 GND.t0 GND.t27 1537.86
R294 GND.t39 GND 1509.39
R295 GND.t33 GND 1509.39
R296 GND.t41 GND.t25 1466.67
R297 GND.t11 GND 1438.19
R298 GND.t14 GND 1438.19
R299 GND.t2 GND 1438.19
R300 GND.t5 GND.t9 1381.23
R301 GND.t12 GND.t37 1381.23
R302 GND.t15 GND 1338.51
R303 GND.t21 GND 1338.51
R304 GND.t17 GND.t41 1210.36
R305 GND.t29 GND.t11 1196.12
R306 GND.t9 GND.t15 1196.12
R307 GND.t23 GND.t14 1196.12
R308 GND.t27 GND.t2 1196.12
R309 GND.t37 GND.t21 1196.12
R310 GND.t31 GND.t19 1196.12
R311 GND.t35 GND.t17 1196.12
R312 GND.t25 GND 925.567
R313 GND.t19 GND 911.327
R314 GND.n28 GND.t26 282.663
R315 GND.n34 GND.t36 278.589
R316 GND.n78 GND.t16 246.506
R317 GND.n22 GND.t22 246.506
R318 GND.n7 GND.n6 210.601
R319 GND.n45 GND.n21 210.601
R320 GND.n90 GND.n2 204.457
R321 GND.n72 GND.n10 204.457
R322 GND.n18 GND.n17 204.457
R323 GND.n32 GND.n26 200.127
R324 GND.n64 GND.t40 158.361
R325 GND.n58 GND.t34 158.361
R326 GND.n24 GND.t20 156.915
R327 GND.n39 GND.t32 154.131
R328 GND.n2 GND.t30 72.8576
R329 GND.n10 GND.t24 72.8576
R330 GND.n17 GND.t28 72.8576
R331 GND.n6 GND.t10 55.7148
R332 GND.n21 GND.t38 55.7148
R333 GND.n92 GND.n91 34.6358
R334 GND.n89 GND.n3 34.6358
R335 GND.n85 GND.n3 34.6358
R336 GND.n85 GND.n84 34.6358
R337 GND.n84 GND.n4 34.6358
R338 GND.n80 GND.n79 34.6358
R339 GND.n77 GND.n8 34.6358
R340 GND.n73 GND.n8 34.6358
R341 GND.n71 GND.n70 34.6358
R342 GND.n70 GND.n11 34.6358
R343 GND.n66 GND.n11 34.6358
R344 GND.n66 GND.n65 34.6358
R345 GND.n63 GND.n13 34.6358
R346 GND.n59 GND.n13 34.6358
R347 GND.n57 GND.n56 34.6358
R348 GND.n56 GND.n15 34.6358
R349 GND.n52 GND.n51 34.6358
R350 GND.n51 GND.n50 34.6358
R351 GND.n50 GND.n19 34.6358
R352 GND.n46 GND.n19 34.6358
R353 GND.n44 GND.n43 34.6358
R354 GND.n6 GND.t6 26.8576
R355 GND.n21 GND.t13 26.8576
R356 GND.n38 GND.n24 25.977
R357 GND.n32 GND.n31 25.977
R358 GND.n31 GND.n28 25.977
R359 GND.n26 GND.t42 25.8467
R360 GND.n26 GND.t18 24.9236
R361 GND.n40 GND.n39 24.4711
R362 GND.n39 GND.n38 24.4711
R363 GND.n92 GND.n0 23.7181
R364 GND.n2 GND.t4 22.3257
R365 GND.n10 GND.t8 22.3257
R366 GND.n17 GND.t1 22.3257
R367 GND.n34 GND.n33 19.9534
R368 GND.n33 GND.n32 18.4476
R369 GND.n7 GND.n4 16.1887
R370 GND.n46 GND.n45 16.1887
R371 GND.n79 GND.n78 15.0593
R372 GND.n43 GND.n22 15.0593
R373 GND.n34 GND.n24 15.0593
R374 GND.n65 GND.n64 10.5417
R375 GND.n59 GND.n58 10.5417
R376 GND.n91 GND.n90 9.41227
R377 GND.n73 GND.n72 9.41227
R378 GND.n18 GND.n15 9.41227
R379 GND GND.n0 9.3031
R380 GND.n29 GND.n28 9.3005
R381 GND.n31 GND.n30 9.3005
R382 GND.n32 GND.n27 9.3005
R383 GND.n33 GND.n25 9.3005
R384 GND.n35 GND.n34 9.3005
R385 GND.n36 GND.n24 9.3005
R386 GND.n93 GND.n92 9.3005
R387 GND.n91 GND.n1 9.3005
R388 GND.n89 GND.n88 9.3005
R389 GND.n87 GND.n3 9.3005
R390 GND.n86 GND.n85 9.3005
R391 GND.n84 GND.n83 9.3005
R392 GND.n82 GND.n4 9.3005
R393 GND.n81 GND.n80 9.3005
R394 GND.n79 GND.n5 9.3005
R395 GND.n77 GND.n76 9.3005
R396 GND.n75 GND.n8 9.3005
R397 GND.n74 GND.n73 9.3005
R398 GND.n71 GND.n9 9.3005
R399 GND.n70 GND.n69 9.3005
R400 GND.n68 GND.n11 9.3005
R401 GND.n67 GND.n66 9.3005
R402 GND.n65 GND.n12 9.3005
R403 GND.n63 GND.n62 9.3005
R404 GND.n61 GND.n13 9.3005
R405 GND.n60 GND.n59 9.3005
R406 GND.n57 GND.n14 9.3005
R407 GND.n56 GND.n55 9.3005
R408 GND.n54 GND.n15 9.3005
R409 GND.n53 GND.n52 9.3005
R410 GND.n51 GND.n16 9.3005
R411 GND.n50 GND.n49 9.3005
R412 GND.n48 GND.n19 9.3005
R413 GND.n47 GND.n46 9.3005
R414 GND.n44 GND.n20 9.3005
R415 GND.n43 GND.n42 9.3005
R416 GND.n41 GND.n40 9.3005
R417 GND.n39 GND.n23 9.3005
R418 GND.n38 GND.n37 9.3005
R419 GND.n64 GND.n63 6.77697
R420 GND.n58 GND.n57 6.77697
R421 GND.n90 GND.n89 6.4005
R422 GND.n72 GND.n71 6.4005
R423 GND.n52 GND.n18 6.4005
R424 GND.n80 GND.n7 2.25932
R425 GND.n45 GND.n44 2.25932
R426 GND.n78 GND.n77 1.50638
R427 GND.n40 GND.n22 1.50638
R428 GND.n93 GND.n1 0.120292
R429 GND.n88 GND.n1 0.120292
R430 GND.n88 GND.n87 0.120292
R431 GND.n87 GND.n86 0.120292
R432 GND.n83 GND.n82 0.120292
R433 GND.n82 GND.n81 0.120292
R434 GND.n81 GND.n5 0.120292
R435 GND.n76 GND.n5 0.120292
R436 GND.n75 GND.n74 0.120292
R437 GND.n74 GND.n9 0.120292
R438 GND.n69 GND.n9 0.120292
R439 GND.n69 GND.n68 0.120292
R440 GND.n67 GND.n12 0.120292
R441 GND.n62 GND.n12 0.120292
R442 GND.n61 GND.n60 0.120292
R443 GND.n60 GND.n14 0.120292
R444 GND.n55 GND.n54 0.120292
R445 GND.n54 GND.n53 0.120292
R446 GND.n53 GND.n16 0.120292
R447 GND.n49 GND.n16 0.120292
R448 GND.n48 GND.n47 0.120292
R449 GND.n47 GND.n20 0.120292
R450 GND.n42 GND.n20 0.120292
R451 GND.n42 GND.n41 0.120292
R452 GND.n37 GND.n23 0.120292
R453 GND.n37 GND.n36 0.120292
R454 GND.n35 GND.n25 0.120292
R455 GND.n27 GND.n25 0.120292
R456 GND.n30 GND.n27 0.120292
R457 GND.n30 GND.n29 0.120292
R458 GND GND.n93 0.0603958
R459 GND.n83 GND 0.0603958
R460 GND GND.n75 0.0603958
R461 GND GND.n67 0.0603958
R462 GND GND.n61 0.0603958
R463 GND.n55 GND 0.0603958
R464 GND GND.n48 0.0603958
R465 GND.n23 GND 0.0603958
R466 GND GND.n35 0.0603958
R467 GND.n86 GND 0.0226354
R468 GND.n76 GND 0.0226354
R469 GND.n68 GND 0.0226354
R470 GND.n62 GND 0.0226354
R471 GND GND.n14 0.0226354
R472 GND.n49 GND 0.0226354
R473 GND.n41 GND 0.0226354
R474 GND.n29 GND 0.0226354
R475 GND.n36 GND 0.0213333
C0 x6.Y A[0] 0.15452f
C1 A[0] A[3] 0.64595f
C2 a_2774_345# x8.X 0.1195f
C3 A[0] A[1] 0.95556f
C4 A[2] Z[1] 0.5171f
C5 VDD x5.Y 1.07455f
C6 x3.X VDD 0.27309f
C7 x2.Y A[2] 0.26854f
C8 VDD Z[2] 0.11952f
C9 a_1293_123# Z[1] 0.11264f
C10 a_842_345# A[1] 0.1956f
C11 a_842_345# A[0] 0.1164f
C12 VDD a_3225_123# 0.21213f
C13 x2.Y A[3] 0.18756f
C14 VDD a_2305_123# 0.20085f
C15 VDD a_2774_345# 0.14375f
C16 x5.Y x7.X 0.16041f
C17 x5.Y A[2] 0.15469f
C18 Z[2] A[2] 0.13145f
C19 a_3225_123# Z[0] 0.11623f
C20 VDD Z[0] 0.24955f
C21 x3.X A[3] 0.21158f
C22 VDD A[2] 0.55184f
C23 VDD x7.X 0.18863f
C24 x3.X a_1293_123# 0.22515f
C25 x3.X A[1] 0.10274f
C26 x7.X a_2305_123# 0.116f
C27 Z[2] A[1] 0.1651f
C28 x7.X a_2774_345# 0.24515f
C29 A[2] a_2774_345# 0.11164f
C30 A[0] Z[2] 0.16044f
C31 VDD x6.Y 0.28563f
C32 VDD A[3] 0.34208f
C33 x6.Y a_2305_123# 0.10994f
C34 VDD a_1293_123# 0.21148f
C35 VDD A[1] 0.26542f
C36 VDD A[0] 0.19617f
C37 x5.Y Z[1] 0.24172f
C38 A[0] a_2305_123# 0.18261f
C39 x3.X a_842_345# 0.12052f
C40 x7.X A[2] 0.26778f
C41 x5.Y x8.X 0.35353f
C42 VDD a_842_345# 0.16191f
C43 A[2] A[3] 0.38787f
C44 x3.X x2.Y 0.38043f
C45 VDD Z[1] 0.74174f
C46 A[2] A[1] 1.39409f
C47 A[0] A[2] 0.17687f
C48 a_3225_123# x8.X 0.23074f
C49 VDD x2.Y 0.87178f
C50 x6.Y A[1] 0.1005f
C51 VDD x8.X 0.27414f
C52 A[3] A[1] 0.18211f
C53 Z[0] GND 0.43644f
C54 Z[1] GND 1.67351f
C55 Z[2] GND 0.40647f
C56 A[3] GND 1.64678f
C57 A[2] GND 1.09977f
C58 A[1] GND 0.57726f
C59 A[0] GND 1.42465f
C60 VDD GND 6.59298f
C61 x8.X GND 0.35379f
C62 x7.X GND 0.29742f
C63 x6.Y GND 0.27992f
C64 x5.Y GND 0.3369f
C65 x3.X GND 0.2208f
C66 x2.Y GND 0.26512f
C67 a_3225_123# GND 0.22683f
C68 a_2774_345# GND 0.20385f
C69 a_2305_123# GND 0.22011f
C70 a_1293_123# GND 0.19924f
C71 a_842_345# GND 0.19699f
C72 VDD.t18 GND 0.10068f
C73 VDD.t29 GND 0.11022f
C74 VDD.t31 GND 0.11181f
C75 VDD.t14 GND 0.14943f
C76 VDD.t25 GND 0.10174f
C77 VDD.t0 GND 0.14572f
C78 VDD.t33 GND 0.14625f
C79 VDD.t36 GND 0.14625f
C80 VDD.t23 GND 0.10174f
C81 VDD.t8 GND 0.14572f
C82 VDD.t6 GND 0.14943f
C83 VDD.t27 GND 0.10174f
C84 VDD.t4 GND 0.21173f
C85 VDD.n0 GND 0.20193f
C86 A[0].n0 GND 0.10058f
C87 A[0].n1 GND 0.12361f
C88 A[0].n2 GND 0.13806f
C89 A[0].n3 GND 0.11965f
C90 A[0].n6 GND 1.46649f
C91 A[0].n7 GND 0.34615f
C92 A[1].t1 GND 0.10898f
C93 A[1].n0 GND 0.20489f
C94 A[1].t5 GND 0.11087f
C95 A[1].n1 GND 0.15514f
C96 A[1].n2 GND 0.30535f
C97 A[1].n3 GND 0.13557f
C98 A[1].n4 GND 0.13037f
C99 A[1].n5 GND 1.79228f
C100 A[1].n6 GND 0.2242f
C101 A[2].n0 GND 0.17543f
C102 A[2].n1 GND 0.14655f
C103 A[2].n2 GND 0.19921f
C104 A[2].n3 GND 0.18254f
C105 A[2].n4 GND 0.8682f
C106 A[2].n5 GND 1.69378f
C107 A[3].n0 GND 0.13607f
C108 A[3].n1 GND 0.14728f
C109 A[3].n3 GND 0.14787f
C110 A[3].n4 GND 0.13429f
C111 A[3].n5 GND 0.93649f
C112 A[3].n6 GND 0.19733f
C113 Z[2].n3 GND 0.14069f
C114 Z[1].n0 GND 0.30735f
C115 Z[1].n3 GND 0.19908f
.ends
