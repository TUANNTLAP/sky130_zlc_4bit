* NGSPICE file created from new_adder_4bit.ext - technology: sky130A

.subckt new_adder_4bit S0 B0 A0 S1 B1 A1 S2 B2 A2 S3 A3 B3 CIN COUT VDD GND
X0 VDD.t16 a_114_247# x2.CIN x1.VPB sky130_fd_pr__pfet_01v8_hvt ad=0.14785 pd=1.345 as=0.26 ps=2.52 w=1 l=0.15
X1 a_246_95# A0.t3 GND.t6 x4.VNB sky130_fd_pr__nfet_01v8 ad=0.063 pd=0.72 as=0.10235 ps=0.995 w=0.42 l=0.15
X2 VDD.t28 A2.t4 a_1201_n819# x3.VPB sky130_fd_pr__pfet_01v8_hvt ad=0.14785 pd=1.345 as=0.0693 ps=0.75 w=0.42 l=0.15
X3 GND.t32 B1.t5 a_908_n179# x4.VNB sky130_fd_pr__nfet_01v8 ad=0.0567 pd=0.69 as=0.1092 ps=1.36 w=0.42 l=0.15
X4 GND.t0 CIN.t1 a_776_95# x4.VNB sky130_fd_pr__nfet_01v8 ad=0.0567 pd=0.69 as=0.0567 ps=0.69 w=0.42 l=0.15
X5 S0.t1 a_1033_95# VDD.t6 x1.VPB sky130_fd_pr__pfet_01v8_hvt ad=0.26 pd=2.52 as=0.14785 ps=1.345 w=1 l=0.15
X6 a_1033_n1185# a_114_n1033# a_776_n1185# x4.VNB sky130_fd_pr__nfet_01v8 ad=0.0693 pd=0.75 as=0.06195 ps=0.715 w=0.42 l=0.15
X7 a_776_n819# A2.t5 VDD.t29 x3.VPB sky130_fd_pr__pfet_01v8_hvt ad=0.06195 pd=0.715 as=0.0567 ps=0.69 w=0.42 l=0.15
X8 a_377_n1459# B3.t7 a_281_n1459# x4.VNB sky130_fd_pr__nfet_01v8 ad=0.0441 pd=0.63 as=0.0693 ps=0.75 w=0.42 l=0.15
X9 a_1129_n1185# x3.CIN a_1033_n1185# x4.VNB sky130_fd_pr__nfet_01v8 ad=0.0441 pd=0.63 as=0.0693 ps=0.75 w=0.42 l=0.15
X10 a_152_n1851# x4.CIN a_377_n1459# x4.VNB sky130_fd_pr__nfet_01v8 ad=0.0693 pd=0.75 as=0.0441 ps=0.63 w=0.42 l=0.15
X11 a_1129_n819# x3.CIN a_1033_n1185# x3.VPB sky130_fd_pr__pfet_01v8_hvt ad=0.0441 pd=0.63 as=0.0693 ps=0.75 w=0.42 l=0.15
X12 GND.t35 B3.t5 a_908_n1459# x4.VNB sky130_fd_pr__nfet_01v8 ad=0.0567 pd=0.69 as=0.1092 ps=1.36 w=0.42 l=0.15
X13 a_545_n179# x2.CIN GND.t15 x4.VNB sky130_fd_pr__nfet_01v8 ad=0.0567 pd=0.69 as=0.0567 ps=0.69 w=0.42 l=0.15
X14 a_908_n1459# A3.t5 GND.t24 x4.VNB sky130_fd_pr__nfet_01v8 ad=0.0567 pd=0.69 as=0.0567 ps=0.69 w=0.42 l=0.15
X15 a_776_n819# B2.t5 VDD.t26 x3.VPB sky130_fd_pr__pfet_01v8_hvt ad=0.0567 pd=0.69 as=0.1092 ps=1.36 w=0.42 l=0.15
X16 a_420_n819# x3.CIN a_114_n1033# x3.VPB sky130_fd_pr__pfet_01v8_hvt ad=0.0567 pd=0.69 as=0.0567 ps=0.69 w=0.42 l=0.15
X17 a_1129_95# CIN.t0 a_1033_95# x4.VNB sky130_fd_pr__nfet_01v8 ad=0.0441 pd=0.63 as=0.0693 ps=0.75 w=0.42 l=0.15
X18 a_545_n1459# a_491_n1569# a_152_n1851# x4.VNB sky130_fd_pr__nfet_01v8 ad=0.06195 pd=0.715 as=0.0693 ps=0.75 w=0.42 l=0.15
X19 x3.CIN a_491_n289# GND.t9 x4.VNB sky130_fd_pr__nfet_01v8 ad=0.169 pd=1.82 as=0.10235 ps=0.995 w=0.65 l=0.15
X20 GND.t4 A0.t0 a_1201_95# x4.VNB sky130_fd_pr__nfet_01v8 ad=0.10235 pd=0.995 as=0.0693 ps=0.75 w=0.42 l=0.15
X21 a_114_247# B0.t7 a_246_461# x1.VPB sky130_fd_pr__pfet_01v8_hvt ad=0.0567 pd=0.69 as=0.063 ps=0.72 w=0.42 l=0.15
X22 GND.t29 A2.t0 a_1201_n1185# x4.VNB sky130_fd_pr__nfet_01v8 ad=0.10235 pd=0.995 as=0.0693 ps=0.75 w=0.42 l=0.15
X23 a_1201_461# B0.t4 a_1129_461# x1.VPB sky130_fd_pr__pfet_01v8_hvt ad=0.0693 pd=0.75 as=0.0441 ps=0.63 w=0.42 l=0.15
X24 GND.t16 a_114_247# x2.CIN x4.VNB sky130_fd_pr__nfet_01v8 ad=0.10235 pd=0.995 as=0.169 ps=1.82 w=0.65 l=0.15
X25 VDD.t32 B1.t1 a_908_n545# x3.VPB sky130_fd_pr__pfet_01v8_hvt ad=0.0567 pd=0.69 as=0.1092 ps=1.36 w=0.42 l=0.15
X26 a_545_n179# a_491_n289# a_152_n571# x4.VNB sky130_fd_pr__nfet_01v8 ad=0.06195 pd=0.715 as=0.0693 ps=0.75 w=0.42 l=0.15
X27 VDD.t3 A0.t4 a_1201_461# x1.VPB sky130_fd_pr__pfet_01v8_hvt ad=0.14785 pd=1.345 as=0.0693 ps=0.75 w=0.42 l=0.15
X28 a_246_n819# A2.t7 VDD.t31 x3.VPB sky130_fd_pr__pfet_01v8_hvt ad=0.063 pd=0.72 as=0.14785 ps=1.345 w=0.42 l=0.15
X29 a_246_461# A0.t7 VDD.t2 x1.VPB sky130_fd_pr__pfet_01v8_hvt ad=0.063 pd=0.72 as=0.14785 ps=1.345 w=0.42 l=0.15
X30 a_377_n1825# B3.t3 a_281_n1825# x4.VPB sky130_fd_pr__pfet_01v8_hvt ad=0.0441 pd=0.63 as=0.0693 ps=0.75 w=0.42 l=0.15
X31 a_1242_n179# B1.t4 a_491_n289# x4.VNB sky130_fd_pr__nfet_01v8 ad=0.063 pd=0.72 as=0.0567 ps=0.69 w=0.42 l=0.15
X32 a_776_95# B0.t1 GND.t1 x4.VNB sky130_fd_pr__nfet_01v8 ad=0.0567 pd=0.69 as=0.1092 ps=1.36 w=0.42 l=0.15
X33 a_1242_n1459# B3.t4 a_491_n1569# x4.VNB sky130_fd_pr__nfet_01v8 ad=0.063 pd=0.72 as=0.0567 ps=0.69 w=0.42 l=0.15
X34 a_152_n1851# x4.CIN a_377_n1825# x4.VPB sky130_fd_pr__pfet_01v8_hvt ad=0.0693 pd=0.75 as=0.0441 ps=0.63 w=0.42 l=0.15
X35 a_776_95# A0.t1 GND.t3 x4.VNB sky130_fd_pr__nfet_01v8 ad=0.06195 pd=0.715 as=0.0567 ps=0.69 w=0.42 l=0.15
X36 a_114_n1033# B2.t7 a_246_n819# x3.VPB sky130_fd_pr__pfet_01v8_hvt ad=0.0567 pd=0.69 as=0.063 ps=0.72 w=0.42 l=0.15
X37 a_377_n179# B1.t7 a_281_n179# x4.VNB sky130_fd_pr__nfet_01v8 ad=0.0441 pd=0.63 as=0.0693 ps=0.75 w=0.42 l=0.15
X38 VDD.t34 B3.t1 a_908_n1825# x4.VPB sky130_fd_pr__pfet_01v8_hvt ad=0.0567 pd=0.69 as=0.1092 ps=1.36 w=0.42 l=0.15
X39 a_545_n545# x2.CIN VDD.t15 x3.VPB sky130_fd_pr__pfet_01v8_hvt ad=0.0567 pd=0.69 as=0.0567 ps=0.69 w=0.42 l=0.15
X40 a_908_n1825# A3.t1 VDD.t23 x4.VPB sky130_fd_pr__pfet_01v8_hvt ad=0.0567 pd=0.69 as=0.0567 ps=0.69 w=0.42 l=0.15
X41 GND.t18 A1.t4 a_1242_n179# x4.VNB sky130_fd_pr__nfet_01v8 ad=0.10235 pd=0.995 as=0.063 ps=0.72 w=0.42 l=0.15
X42 a_491_n1569# x4.CIN a_908_n1459# x4.VNB sky130_fd_pr__nfet_01v8 ad=0.0567 pd=0.69 as=0.0567 ps=0.69 w=0.42 l=0.15
X43 a_1033_n1185# a_114_n1033# a_776_n819# x3.VPB sky130_fd_pr__pfet_01v8_hvt ad=0.0693 pd=0.75 as=0.06195 ps=0.715 w=0.42 l=0.15
X44 a_908_n179# A1.t5 GND.t19 x4.VNB sky130_fd_pr__nfet_01v8 ad=0.0567 pd=0.69 as=0.0567 ps=0.69 w=0.42 l=0.15
X45 GND.t14 a_152_n1851# S3.t0 x4.VNB sky130_fd_pr__nfet_01v8 ad=0.10235 pd=0.995 as=0.169 ps=1.82 w=0.65 l=0.15
X46 a_420_95# CIN.t2 a_114_247# x4.VNB sky130_fd_pr__nfet_01v8 ad=0.0567 pd=0.69 as=0.0567 ps=0.69 w=0.42 l=0.15
X47 a_545_n1825# a_491_n1569# a_152_n1851# x4.VPB sky130_fd_pr__pfet_01v8_hvt ad=0.06195 pd=0.715 as=0.0693 ps=0.75 w=0.42 l=0.15
X48 a_545_n545# a_491_n289# a_152_n571# x3.VPB sky130_fd_pr__pfet_01v8_hvt ad=0.06195 pd=0.715 as=0.0693 ps=0.75 w=0.42 l=0.15
X49 S2.t0 a_1033_n1185# GND.t8 x4.VNB sky130_fd_pr__nfet_01v8 ad=0.169 pd=1.82 as=0.10235 ps=0.995 w=0.65 l=0.15
X50 a_1129_461# CIN.t3 a_1033_95# x1.VPB sky130_fd_pr__pfet_01v8_hvt ad=0.0441 pd=0.63 as=0.0693 ps=0.75 w=0.42 l=0.15
X51 GND.t25 A3.t4 a_1242_n1459# x4.VNB sky130_fd_pr__nfet_01v8 ad=0.10235 pd=0.995 as=0.063 ps=0.72 w=0.42 l=0.15
X52 a_152_n571# x2.CIN a_377_n179# x4.VNB sky130_fd_pr__nfet_01v8 ad=0.0693 pd=0.75 as=0.0441 ps=0.63 w=0.42 l=0.15
X53 a_1242_n545# B1.t0 a_491_n289# x3.VPB sky130_fd_pr__pfet_01v8_hvt ad=0.063 pd=0.72 as=0.0567 ps=0.69 w=0.42 l=0.15
X54 GND.t34 B3.t6 a_545_n1459# x4.VNB sky130_fd_pr__nfet_01v8 ad=0.1092 pd=1.36 as=0.0567 ps=0.69 w=0.42 l=0.15
X55 a_1242_n1825# B3.t0 a_491_n1569# x4.VPB sky130_fd_pr__pfet_01v8_hvt ad=0.063 pd=0.72 as=0.0567 ps=0.69 w=0.42 l=0.15
X56 VDD.t30 A2.t6 a_420_n819# x3.VPB sky130_fd_pr__pfet_01v8_hvt ad=0.0567 pd=0.69 as=0.0567 ps=0.69 w=0.42 l=0.15
X57 a_377_n545# B1.t3 a_281_n545# x3.VPB sky130_fd_pr__pfet_01v8_hvt ad=0.0441 pd=0.63 as=0.0693 ps=0.75 w=0.42 l=0.15
X58 COUT.t0 a_491_n1569# GND.t13 x4.VNB sky130_fd_pr__nfet_01v8 ad=0.169 pd=1.82 as=0.10235 ps=0.995 w=0.65 l=0.15
X59 a_491_n1569# x4.CIN a_908_n1825# x4.VPB sky130_fd_pr__pfet_01v8_hvt ad=0.0567 pd=0.69 as=0.0567 ps=0.69 w=0.42 l=0.15
X60 a_545_n1459# x4.CIN GND.t17 x4.VNB sky130_fd_pr__nfet_01v8 ad=0.0567 pd=0.69 as=0.0567 ps=0.69 w=0.42 l=0.15
X61 a_1201_n819# B2.t4 a_1129_n819# x3.VPB sky130_fd_pr__pfet_01v8_hvt ad=0.0693 pd=0.75 as=0.0441 ps=0.63 w=0.42 l=0.15
X62 VDD.t18 A1.t0 a_1242_n545# x3.VPB sky130_fd_pr__pfet_01v8_hvt ad=0.14785 pd=1.345 as=0.063 ps=0.72 w=0.42 l=0.15
X63 x3.CIN a_491_n289# VDD.t8 x3.VPB sky130_fd_pr__pfet_01v8_hvt ad=0.26 pd=2.52 as=0.14785 ps=1.345 w=1 l=0.15
X64 a_908_n545# A1.t1 VDD.t19 x3.VPB sky130_fd_pr__pfet_01v8_hvt ad=0.0567 pd=0.69 as=0.0567 ps=0.69 w=0.42 l=0.15
X65 GND.t20 A1.t6 a_545_n179# x4.VNB sky130_fd_pr__nfet_01v8 ad=0.0567 pd=0.69 as=0.06195 ps=0.715 w=0.42 l=0.15
X66 a_114_247# B0.t3 a_246_95# x4.VNB sky130_fd_pr__nfet_01v8 ad=0.0567 pd=0.69 as=0.063 ps=0.72 w=0.42 l=0.15
X67 GND.t11 x3.CIN a_776_n1185# x4.VNB sky130_fd_pr__nfet_01v8 ad=0.0567 pd=0.69 as=0.0567 ps=0.69 w=0.42 l=0.15
X68 a_420_n1185# x3.CIN a_114_n1033# x4.VNB sky130_fd_pr__nfet_01v8 ad=0.0567 pd=0.69 as=0.0567 ps=0.69 w=0.42 l=0.15
X69 VDD.t22 A3.t0 a_1242_n1825# x4.VPB sky130_fd_pr__pfet_01v8_hvt ad=0.14785 pd=1.345 as=0.063 ps=0.72 w=0.42 l=0.15
X70 GND.t12 a_114_n1033# x4.CIN x4.VNB sky130_fd_pr__nfet_01v8 ad=0.10235 pd=0.995 as=0.169 ps=1.82 w=0.65 l=0.15
X71 a_152_n571# x2.CIN a_377_n545# x3.VPB sky130_fd_pr__pfet_01v8_hvt ad=0.0693 pd=0.75 as=0.0441 ps=0.63 w=0.42 l=0.15
X72 a_776_n1185# B2.t1 GND.t26 x4.VNB sky130_fd_pr__nfet_01v8 ad=0.0567 pd=0.69 as=0.1092 ps=1.36 w=0.42 l=0.15
X73 GND.t10 a_152_n571# S1.t0 x4.VNB sky130_fd_pr__nfet_01v8 ad=0.10235 pd=0.995 as=0.169 ps=1.82 w=0.65 l=0.15
X74 GND.t5 A0.t2 a_420_95# x4.VNB sky130_fd_pr__nfet_01v8 ad=0.0567 pd=0.69 as=0.0567 ps=0.69 w=0.42 l=0.15
X75 VDD.t35 B3.t2 a_545_n1825# x4.VPB sky130_fd_pr__pfet_01v8_hvt ad=0.1092 pd=1.36 as=0.0567 ps=0.69 w=0.42 l=0.15
X76 GND.t22 A3.t6 a_545_n1459# x4.VNB sky130_fd_pr__nfet_01v8 ad=0.0567 pd=0.69 as=0.06195 ps=0.715 w=0.42 l=0.15
X77 a_1033_95# a_114_247# a_776_461# x1.VPB sky130_fd_pr__pfet_01v8_hvt ad=0.0693 pd=0.75 as=0.06195 ps=0.715 w=0.42 l=0.15
X78 a_491_n289# x2.CIN a_908_n179# x4.VNB sky130_fd_pr__nfet_01v8 ad=0.0567 pd=0.69 as=0.0567 ps=0.69 w=0.42 l=0.15
X79 a_420_461# B0.t6 VDD.t1 x1.VPB sky130_fd_pr__pfet_01v8_hvt ad=0.1092 pd=1.36 as=0.0567 ps=0.69 w=0.42 l=0.15
X80 VDD.t14 a_152_n1851# S3.t1 x4.VPB sky130_fd_pr__pfet_01v8_hvt ad=0.14785 pd=1.345 as=0.26 ps=2.52 w=1 l=0.15
X81 a_545_n1825# x4.CIN VDD.t17 x4.VPB sky130_fd_pr__pfet_01v8_hvt ad=0.0567 pd=0.69 as=0.0567 ps=0.69 w=0.42 l=0.15
X82 a_281_n1459# A3.t7 GND.t23 x4.VNB sky130_fd_pr__nfet_01v8 ad=0.0693 pd=0.75 as=0.10235 ps=0.995 w=0.42 l=0.15
X83 GND.t33 B1.t6 a_545_n179# x4.VNB sky130_fd_pr__nfet_01v8 ad=0.1092 pd=1.36 as=0.0567 ps=0.69 w=0.42 l=0.15
X84 VDD.t10 x3.CIN a_776_n819# x3.VPB sky130_fd_pr__pfet_01v8_hvt ad=0.0567 pd=0.69 as=0.0567 ps=0.69 w=0.42 l=0.15
X85 VDD.t20 A1.t2 a_545_n545# x3.VPB sky130_fd_pr__pfet_01v8_hvt ad=0.0567 pd=0.69 as=0.06195 ps=0.715 w=0.42 l=0.15
X86 VDD.t5 A0.t6 a_420_461# x1.VPB sky130_fd_pr__pfet_01v8_hvt ad=0.0567 pd=0.69 as=0.0567 ps=0.69 w=0.42 l=0.15
X87 S2.t1 a_1033_n1185# VDD.t7 x3.VPB sky130_fd_pr__pfet_01v8_hvt ad=0.26 pd=2.52 as=0.14785 ps=1.345 w=1 l=0.15
X88 GND.t31 A2.t2 a_420_n1185# x4.VNB sky130_fd_pr__nfet_01v8 ad=0.0567 pd=0.69 as=0.0567 ps=0.69 w=0.42 l=0.15
X89 a_281_n179# A1.t7 GND.t21 x4.VNB sky130_fd_pr__nfet_01v8 ad=0.0693 pd=0.75 as=0.10235 ps=0.995 w=0.42 l=0.15
X90 a_776_n1185# A2.t1 GND.t28 x4.VNB sky130_fd_pr__nfet_01v8 ad=0.06195 pd=0.715 as=0.0567 ps=0.69 w=0.42 l=0.15
X91 a_1033_95# a_114_247# a_776_95# x4.VNB sky130_fd_pr__nfet_01v8 ad=0.0693 pd=0.75 as=0.06195 ps=0.715 w=0.42 l=0.15
X92 a_776_461# A0.t5 VDD.t4 x1.VPB sky130_fd_pr__pfet_01v8_hvt ad=0.06195 pd=0.715 as=0.0567 ps=0.69 w=0.42 l=0.15
X93 a_420_n819# B2.t6 VDD.t27 x3.VPB sky130_fd_pr__pfet_01v8_hvt ad=0.1092 pd=1.36 as=0.0567 ps=0.69 w=0.42 l=0.15
X94 COUT.t1 a_491_n1569# VDD.t13 x4.VPB sky130_fd_pr__pfet_01v8_hvt ad=0.26 pd=2.52 as=0.14785 ps=1.345 w=1 l=0.15
X95 a_246_n1185# A2.t3 GND.t30 x4.VNB sky130_fd_pr__nfet_01v8 ad=0.063 pd=0.72 as=0.10235 ps=0.995 w=0.42 l=0.15
X96 a_420_461# CIN.t5 a_114_247# x1.VPB sky130_fd_pr__pfet_01v8_hvt ad=0.0567 pd=0.69 as=0.0567 ps=0.69 w=0.42 l=0.15
X97 VDD.t24 A3.t2 a_545_n1825# x4.VPB sky130_fd_pr__pfet_01v8_hvt ad=0.0567 pd=0.69 as=0.06195 ps=0.715 w=0.42 l=0.15
X98 a_1201_95# B0.t0 a_1129_95# x4.VNB sky130_fd_pr__nfet_01v8 ad=0.0693 pd=0.75 as=0.0441 ps=0.63 w=0.42 l=0.15
X99 a_1201_n1185# B2.t0 a_1129_n1185# x4.VNB sky130_fd_pr__nfet_01v8 ad=0.0693 pd=0.75 as=0.0441 ps=0.63 w=0.42 l=0.15
X100 a_491_n289# x2.CIN a_908_n545# x3.VPB sky130_fd_pr__pfet_01v8_hvt ad=0.0567 pd=0.69 as=0.0567 ps=0.69 w=0.42 l=0.15
X101 VDD.t12 CIN.t4 a_776_461# x1.VPB sky130_fd_pr__pfet_01v8_hvt ad=0.0567 pd=0.69 as=0.0567 ps=0.69 w=0.42 l=0.15
X102 a_420_95# B0.t2 GND.t2 x4.VNB sky130_fd_pr__nfet_01v8 ad=0.1092 pd=1.36 as=0.0567 ps=0.69 w=0.42 l=0.15
X103 a_281_n1825# A3.t3 VDD.t25 x4.VPB sky130_fd_pr__pfet_01v8_hvt ad=0.0693 pd=0.75 as=0.14785 ps=1.345 w=0.42 l=0.15
X104 VDD.t33 B1.t2 a_545_n545# x3.VPB sky130_fd_pr__pfet_01v8_hvt ad=0.1092 pd=1.36 as=0.0567 ps=0.69 w=0.42 l=0.15
X105 VDD.t11 a_114_n1033# x4.CIN x3.VPB sky130_fd_pr__pfet_01v8_hvt ad=0.14785 pd=1.345 as=0.26 ps=2.52 w=1 l=0.15
X106 VDD.t9 a_152_n571# S1.t1 x3.VPB sky130_fd_pr__pfet_01v8_hvt ad=0.14785 pd=1.345 as=0.26 ps=2.52 w=1 l=0.15
X107 a_281_n545# A1.t3 VDD.t21 x3.VPB sky130_fd_pr__pfet_01v8_hvt ad=0.0693 pd=0.75 as=0.14785 ps=1.345 w=0.42 l=0.15
X108 a_114_n1033# B2.t3 a_246_n1185# x4.VNB sky130_fd_pr__nfet_01v8 ad=0.0567 pd=0.69 as=0.063 ps=0.72 w=0.42 l=0.15
X109 a_420_n1185# B2.t2 GND.t27 x4.VNB sky130_fd_pr__nfet_01v8 ad=0.1092 pd=1.36 as=0.0567 ps=0.69 w=0.42 l=0.15
X110 S0.t0 a_1033_95# GND.t7 x4.VNB sky130_fd_pr__nfet_01v8 ad=0.169 pd=1.82 as=0.10235 ps=0.995 w=0.65 l=0.15
X111 a_776_461# B0.t5 VDD.t0 x1.VPB sky130_fd_pr__pfet_01v8_hvt ad=0.0567 pd=0.69 as=0.1092 ps=1.36 w=0.42 l=0.15
R0 COUT.n2 COUT.t1 782
R1 COUT.t1 COUT.n1 744.115
R2 COUT COUT.t0 211.647
R3 COUT.n1 COUT 73.7552
R4 COUT.n0 COUT 13.922
R5 COUT COUT.n0 12.3082
R6 COUT.n1 COUT 8.86204
R7 COUT COUT.n2 2.46204
R8 COUT.n2 COUT.n0 1.96973
R9 S3.n4 S3.t1 755.481
R10 S3.t1 S3.n3 755.481
R11 S3 S3.t0 211.043
R12 S3.n2 S3 9.55194
R13 S3.n3 S3 8.1605
R14 S3.n1 S3 8.14595
R15 S3.n0 S3 6.8805
R16 S3.n4 S3 6.2405
R17 S3.n1 S3 5.04292
R18 S3 S3.n0 4.84898
R19 S3 S3.n4 4.6405
R20 S3.n0 S3 4.0005
R21 S3.n3 S3 2.7205
R22 S3 S3.n2 2.5605
R23 S3.n2 S3.n1 1.6005
R24 B3.n10 B3.t4 384.529
R25 B3.n0 B3.t7 373.283
R26 B3.n4 B3.t5 351.861
R27 B3.n5 B3.t1 297.233
R28 B3.n6 B3.n4 214.362
R29 B3.n0 B3.t3 167.63
R30 B3.n11 B3.n10 158.768
R31 B3.n10 B3.t0 156.382
R32 B3.n7 B3.n6 152
R33 B3.n1 B3.n0 152
R34 B3.n4 B3.t6 109.215
R35 B3.n5 B3.t2 102.779
R36 B3.n6 B3.n5 47.4474
R37 B3.n8 B3.n7 11.7894
R38 B3.n2 B3.n1 10.3005
R39 B3.n1 B3 10.2005
R40 B3.n12 B3.n11 9.3005
R41 B3.n7 B3 5.86717
R42 B3.n11 B3 2.50165
R43 B3.n9 B3 2.313
R44 B3 B3.n3 1.79514
R45 B3 B3.n9 1.40229
R46 B3.n12 B3 1.25118
R47 B3.n3 B3 0.259429
R48 B3.n3 B3.n2 0.0793043
R49 B3.n2 B3 0.0793043
R50 B3.n9 B3.n8 0.0793043
R51 B3.n8 B3 0.0793043
R52 B3 B3.n12 0.0793043
R53 A3.n4 A3.t2 373.283
R54 A3.n0 A3.t3 347.577
R55 A3.n12 A3.t0 334.723
R56 A3.n8 A3.t1 323.476
R57 A3.n8 A3.t5 217.436
R58 A3.n12 A3.t4 206.19
R59 A3.n0 A3.t7 193.337
R60 A3.n4 A3.t6 167.63
R61 A3.n9 A3.n8 160.534
R62 A3.n13 A3.n12 159.315
R63 A3.n5 A3.n4 157.12
R64 A3.n1 A3.n0 156
R65 A3.n2 A3.n1 9.3005
R66 A3.n6 A3.n5 9.3005
R67 A3.n10 A3.n9 9.3005
R68 A3.n14 A3.n13 9.3005
R69 A3.n1 A3 4.8005
R70 A3.n13 A3 3.88621
R71 A3.n11 A3 3.563
R72 A3.n9 A3 3.29747
R73 A3.n5 A3 2.90183
R74 A3.n7 A3 1.90229
R75 A3 A3.n7 1.40229
R76 A3 A3.n3 1.38443
R77 A3 A3.n11 0.973714
R78 A3.n14 A3 0.891804
R79 A3.n3 A3 0.259429
R80 A3.n3 A3.n2 0.0793043
R81 A3.n2 A3 0.0793043
R82 A3.n7 A3.n6 0.0793043
R83 A3.n6 A3 0.0793043
R84 A3.n11 A3.n10 0.0793043
R85 A3.n10 A3 0.0793043
R86 A3 A3.n14 0.0793043
R87 S2.t1 S2 758.202
R88 S2.n0 S2.t1 755.481
R89 S2.n3 S2.t0 209.923
R90 S2 S2.n4 11.4429
R91 S2.n2 S2 10.0853
R92 S2.n2 S2 9.4055
R93 S2.n1 S2.n0 8.8005
R94 S2 S2.n3 6.5605
R95 S2.n3 S2 4.3205
R96 S2 S2.n2 3.10353
R97 S2.n4 S2 1.74595
R98 S2 S2.n1 1.55202
R99 S2.n4 S2 1.4405
R100 S2.n1 S2 1.2805
R101 S2.n0 S2 0.8005
R102 B2.n9 B2.t3 384.529
R103 B2.n0 B2.t0 373.283
R104 B2.n4 B2.t2 351.861
R105 B2.n3 B2.t6 297.233
R106 B2.n5 B2.n4 214.362
R107 B2.n0 B2.t4 167.63
R108 B2.n10 B2.n9 157.921
R109 B2.n1 B2.n0 156.571
R110 B2.n9 B2.t7 156.382
R111 B2.n6 B2.n5 152
R112 B2.n4 B2.t1 109.215
R113 B2.n3 B2.t5 102.659
R114 B2.n5 B2.n3 47.4474
R115 B2.n7 B2.n6 10.2702
R116 B2.n6 B2 9.69747
R117 B2 B2.n1 9.37931
R118 B2.n11 B2.n10 9.3005
R119 B2.n10 B2 2.7205
R120 B2.n1 B2 2.59098
R121 B2.n2 B2 1.92014
R122 B2.n2 B2 1.79514
R123 B2.n8 B2 1.40229
R124 B2.n8 B2 0.259429
R125 B2.n7 B2.n2 0.0793043
R126 B2 B2.n7 0.0793043
R127 B2.n11 B2.n8 0.0793043
R128 B2 B2.n11 0.0793043
R129 A2.n3 A2.t5 373.283
R130 A2.n0 A2.t4 347.577
R131 A2.n11 A2.t7 334.723
R132 A2.n7 A2.t6 323.476
R133 A2.n7 A2.t2 217.436
R134 A2.n11 A2.t3 206.19
R135 A2.n0 A2.t0 193.337
R136 A2.n3 A2.t1 167.63
R137 A2.n12 A2.n11 152
R138 A2.n8 A2.n7 152
R139 A2.n4 A2.n3 152
R140 A2.n1 A2.n0 152
R141 A2.n9 A2.n8 17.8338
R142 A2.n1 A2 14.6672
R143 A2.n5 A2.n4 14.4205
R144 A2 A2.n1 13.3793
R145 A2.n13 A2.n12 10.4641
R146 A2.n8 A2 3.29747
R147 A2.n2 A2 3.15229
R148 A2.n4 A2 2.90183
R149 A2.n12 A2 2.13383
R150 A2.n6 A2 1.49157
R151 A2.n6 A2 1.40229
R152 A2.n2 A2 1.38443
R153 A2.n10 A2 0.973714
R154 A2.n10 A2 0.259429
R155 A2.n5 A2.n2 0.0793043
R156 A2 A2.n5 0.0793043
R157 A2.n9 A2.n6 0.0793043
R158 A2 A2.n9 0.0793043
R159 A2.n13 A2.n10 0.0793043
R160 A2 A2.n13 0.0793043
R161 S1.n3 S1.t1 755.481
R162 S1.t1 S1.n2 755.481
R163 S1 S1.t0 211.043
R164 S1.n1 S1 9.69747
R165 S1.n1 S1 9.55258
R166 S1.n2 S1 8.1605
R167 S1 S1.n4 8.14595
R168 S1.n0 S1 6.8805
R169 S1.n3 S1 6.2405
R170 S1.n4 S1 5.04292
R171 S1 S1.n0 4.84898
R172 S1 S1.n3 4.6405
R173 S1.n4 S1 4.1605
R174 S1.n0 S1 4.0005
R175 S1 S1.n1 3.49141
R176 S1.n2 S1 2.7205
R177 B1.n10 B1.t4 384.529
R178 B1.n0 B1.t7 373.283
R179 B1.n4 B1.t5 351.861
R180 B1.n5 B1.t1 297.233
R181 B1.n6 B1.n4 214.362
R182 B1.n0 B1.t3 167.63
R183 B1.n11 B1.n10 158.768
R184 B1.n10 B1.t0 156.382
R185 B1.n7 B1.n6 152
R186 B1.n1 B1.n0 152
R187 B1.n4 B1.t6 109.215
R188 B1.n5 B1.t2 102.779
R189 B1.n6 B1.n5 47.4474
R190 B1.n8 B1.n7 11.7894
R191 B1.n2 B1.n1 10.3005
R192 B1.n1 B1 10.2005
R193 B1.n12 B1.n11 9.3005
R194 B1.n7 B1 5.86717
R195 B1.n11 B1 2.50165
R196 B1.n9 B1 2.313
R197 B1 B1.n3 1.79514
R198 B1 B1.n9 1.40229
R199 B1.n12 B1 1.25118
R200 B1.n3 B1 0.259429
R201 B1.n3 B1.n2 0.0793043
R202 B1.n2 B1 0.0793043
R203 B1.n9 B1.n8 0.0793043
R204 B1.n8 B1 0.0793043
R205 B1 B1.n12 0.0793043
R206 A1.n4 A1.t2 373.283
R207 A1.n0 A1.t3 347.577
R208 A1.n12 A1.t0 334.723
R209 A1.n8 A1.t1 323.476
R210 A1.n8 A1.t5 217.436
R211 A1.n12 A1.t4 206.19
R212 A1.n0 A1.t7 193.337
R213 A1.n4 A1.t6 167.63
R214 A1.n9 A1.n8 160.534
R215 A1.n13 A1.n12 159.315
R216 A1.n5 A1.n4 157.12
R217 A1.n1 A1.n0 156
R218 A1.n2 A1.n1 9.3005
R219 A1.n6 A1.n5 9.3005
R220 A1.n10 A1.n9 9.3005
R221 A1.n14 A1.n13 9.3005
R222 A1.n1 A1 4.8005
R223 A1.n13 A1 3.88621
R224 A1.n11 A1 3.563
R225 A1.n9 A1 3.29747
R226 A1.n5 A1 2.90183
R227 A1.n7 A1 1.90229
R228 A1 A1.n7 1.40229
R229 A1 A1.n3 1.38443
R230 A1 A1.n11 0.973714
R231 A1.n14 A1 0.891804
R232 A1.n3 A1 0.259429
R233 A1.n3 A1.n2 0.0793043
R234 A1.n2 A1 0.0793043
R235 A1.n7 A1.n6 0.0793043
R236 A1.n6 A1 0.0793043
R237 A1.n11 A1.n10 0.0793043
R238 A1.n10 A1 0.0793043
R239 A1 A1.n14 0.0793043
R240 S0.t1 S0 758.202
R241 S0.n4 S0.t1 755.481
R242 S0.n1 S0.t0 209.923
R243 S0 S0.n2 11.4429
R244 S0.n0 S0 9.64227
R245 S0.n4 S0.n3 8.8005
R246 S0 S0.n0 8.3205
R247 S0 S0.n1 6.5605
R248 S0.n1 S0 4.3205
R249 S0 S0.n0 2.5605
R250 S0.n2 S0 1.74595
R251 S0.n3 S0 1.55202
R252 S0.n2 S0 1.4405
R253 S0.n3 S0 1.2805
R254 S0 S0.n4 0.8005
R255 GND.n98 GND.t1 239.281
R256 GND.n11 GND.t33 239.281
R257 GND.n90 GND.t26 239.281
R258 GND.n18 GND.t34 239.281
R259 GND.n114 GND.n2 199.739
R260 GND.n36 GND.n33 199.739
R261 GND.n72 GND.n71 199.739
R262 GND.n48 GND.n47 199.739
R263 GND.n31 GND.n30 198.964
R264 GND.n96 GND.n14 198.964
R265 GND.n104 GND.n7 198.964
R266 GND.n110 GND.n109 198.964
R267 GND.n101 GND.n10 198.964
R268 GND.n28 GND.n27 198.964
R269 GND.n52 GND.n51 198.964
R270 GND.n62 GND.n61 198.964
R271 GND.n64 GND.n63 198.964
R272 GND.n78 GND.n77 198.964
R273 GND.n67 GND.n65 198.964
R274 GND.n58 GND.n23 198.964
R275 GND.n2 GND.t6 60.0005
R276 GND.n33 GND.t18 60.0005
R277 GND.n71 GND.t30 60.0005
R278 GND.n47 GND.t25 60.0005
R279 GND.n30 GND.t7 46.8576
R280 GND.n109 GND.t10 46.8576
R281 GND.n51 GND.t8 46.8576
R282 GND.n77 GND.t14 46.8576
R283 GND.n35 GND.n34 43.9358
R284 GND.n50 GND.n46 43.9358
R285 GND.n30 GND.t4 38.5719
R286 GND.n14 GND.t3 38.5719
R287 GND.n14 GND.t0 38.5719
R288 GND.n7 GND.t2 38.5719
R289 GND.n7 GND.t5 38.5719
R290 GND.n109 GND.t21 38.5719
R291 GND.n10 GND.t15 38.5719
R292 GND.n10 GND.t20 38.5719
R293 GND.n27 GND.t19 38.5719
R294 GND.n27 GND.t32 38.5719
R295 GND.n51 GND.t29 38.5719
R296 GND.n61 GND.t28 38.5719
R297 GND.n61 GND.t11 38.5719
R298 GND.n63 GND.t27 38.5719
R299 GND.n63 GND.t31 38.5719
R300 GND.n77 GND.t23 38.5719
R301 GND.n65 GND.t17 38.5719
R302 GND.n65 GND.t22 38.5719
R303 GND.n23 GND.t24 38.5719
R304 GND.n23 GND.t35 38.5719
R305 GND.n41 GND.n40 34.6358
R306 GND.n42 GND.n41 34.6358
R307 GND.n42 GND.n13 34.6358
R308 GND.n106 GND.n105 34.6358
R309 GND.n106 GND.n1 34.6358
R310 GND.n102 GND.n4 34.6358
R311 GND.n108 GND.n4 34.6358
R312 GND.n111 GND.n108 34.6358
R313 GND.n38 GND.n37 34.6358
R314 GND.n37 GND.n29 34.6358
R315 GND.n54 GND.n53 34.6358
R316 GND.n54 GND.n20 34.6358
R317 GND.n60 GND.n20 34.6358
R318 GND.n84 GND.n83 34.6358
R319 GND.n83 GND.n82 34.6358
R320 GND.n69 GND.n68 34.6358
R321 GND.n74 GND.n69 34.6358
R322 GND.n75 GND.n74 34.6358
R323 GND.n56 GND.n24 34.6358
R324 GND.n57 GND.n56 34.6358
R325 GND.n96 GND.n13 31.624
R326 GND.n102 GND.n101 31.624
R327 GND.n62 GND.n60 31.624
R328 GND.n68 GND.n67 31.624
R329 GND.n115 GND.n114 30.7593
R330 GND.n36 GND.n35 30.7593
R331 GND.n76 GND.n72 30.7593
R332 GND.n48 GND.n46 30.7593
R333 GND.n104 GND.n6 27.1064
R334 GND.n28 GND.n16 27.1064
R335 GND.n89 GND.n64 27.1064
R336 GND.n58 GND.n22 27.1064
R337 GND.n98 GND.n97 25.6005
R338 GND.n100 GND.n11 25.6005
R339 GND.n91 GND.n90 25.6005
R340 GND.n66 GND.n18 25.6005
R341 GND.n2 GND.t16 25.4291
R342 GND.n33 GND.t9 25.4291
R343 GND.n71 GND.t12 25.4291
R344 GND.n47 GND.t13 25.4291
R345 GND.n114 GND.n1 22.9652
R346 GND.n38 GND.n36 22.9652
R347 GND.n82 GND.n72 22.9652
R348 GND.n48 GND.n24 22.9652
R349 GND.n98 GND.n6 18.824
R350 GND.n16 GND.n11 18.824
R351 GND.n90 GND.n89 18.824
R352 GND.n22 GND.n18 18.824
R353 GND.n105 GND.n104 17.3181
R354 GND.n29 GND.n28 17.3181
R355 GND.n84 GND.n64 17.3181
R356 GND.n58 GND.n57 17.3181
R357 GND.n73 GND.n3 16.7052
R358 GND.n87 GND.n8 16.7052
R359 GND.n94 GND.n93 16.7052
R360 GND.n45 GND.n44 16.7052
R361 GND.n110 GND.n0 13.3148
R362 GND.n79 GND.n78 13.3148
R363 GND.n97 GND.n96 12.8005
R364 GND.n101 GND.n100 12.8005
R365 GND.n91 GND.n62 12.8005
R366 GND.n67 GND.n66 12.8005
R367 GND.n49 GND.n48 9.3005
R368 GND.n25 GND.n24 9.3005
R369 GND.n56 GND.n55 9.3005
R370 GND.n57 GND.n21 9.3005
R371 GND.n59 GND.n58 9.3005
R372 GND.n22 GND.n17 9.3005
R373 GND.n92 GND.n18 9.3005
R374 GND.n66 GND.n19 9.3005
R375 GND.n88 GND.n67 9.3005
R376 GND.n86 GND.n68 9.3005
R377 GND.n85 GND.n69 9.3005
R378 GND.n74 GND.n70 9.3005
R379 GND.n81 GND.n75 9.3005
R380 GND.n80 GND.n72 9.3005
R381 GND.n50 GND.n49 9.3005
R382 GND.n53 GND.n25 9.3005
R383 GND.n55 GND.n54 9.3005
R384 GND.n21 GND.n20 9.3005
R385 GND.n60 GND.n59 9.3005
R386 GND.n62 GND.n17 9.3005
R387 GND.n92 GND.n91 9.3005
R388 GND.n90 GND.n19 9.3005
R389 GND.n89 GND.n88 9.3005
R390 GND.n86 GND.n64 9.3005
R391 GND.n85 GND.n84 9.3005
R392 GND.n83 GND.n70 9.3005
R393 GND.n82 GND.n81 9.3005
R394 GND.n36 GND.n32 9.3005
R395 GND.n39 GND.n38 9.3005
R396 GND.n37 GND.n26 9.3005
R397 GND.n43 GND.n29 9.3005
R398 GND.n28 GND.n15 9.3005
R399 GND.n95 GND.n16 9.3005
R400 GND.n12 GND.n11 9.3005
R401 GND.n100 GND.n99 9.3005
R402 GND.n101 GND.n9 9.3005
R403 GND.n103 GND.n102 9.3005
R404 GND.n5 GND.n4 9.3005
R405 GND.n108 GND.n107 9.3005
R406 GND.n112 GND.n111 9.3005
R407 GND.n114 GND.n113 9.3005
R408 GND.n34 GND.n32 9.3005
R409 GND.n40 GND.n39 9.3005
R410 GND.n41 GND.n26 9.3005
R411 GND.n43 GND.n42 9.3005
R412 GND.n15 GND.n13 9.3005
R413 GND.n96 GND.n95 9.3005
R414 GND.n97 GND.n12 9.3005
R415 GND.n99 GND.n98 9.3005
R416 GND.n9 GND.n6 9.3005
R417 GND.n104 GND.n103 9.3005
R418 GND.n105 GND.n5 9.3005
R419 GND.n107 GND.n106 9.3005
R420 GND.n112 GND.n1 9.3005
R421 GND.n34 GND.n31 5.64756
R422 GND.n52 GND.n50 5.64756
R423 GND.n40 GND.n31 4.14168
R424 GND.n111 GND.n110 4.14168
R425 GND.n53 GND.n52 4.14168
R426 GND.n78 GND.n75 4.14168
R427 GND.n49 GND.n25 0.0603958
R428 GND.n55 GND.n25 0.0603958
R429 GND.n59 GND.n21 0.0603958
R430 GND.n59 GND.n17 0.0603958
R431 GND.n92 GND.n19 0.0603958
R432 GND.n88 GND.n19 0.0603958
R433 GND.n86 GND.n85 0.0603958
R434 GND.n85 GND.n70 0.0603958
R435 GND.n81 GND.n80 0.0603958
R436 GND.n39 GND.n32 0.0603958
R437 GND.n39 GND.n26 0.0603958
R438 GND.n43 GND.n15 0.0603958
R439 GND.n95 GND.n15 0.0603958
R440 GND.n99 GND.n12 0.0603958
R441 GND.n99 GND.n9 0.0603958
R442 GND.n103 GND.n5 0.0603958
R443 GND.n107 GND.n5 0.0603958
R444 GND.n113 GND.n112 0.0603958
R445 GND.n81 GND.n73 0.0512812
R446 GND.n112 GND.n3 0.0512812
R447 GND.n79 GND.n76 0.0503767
R448 GND.n115 GND.n0 0.0503767
R449 GND.n49 GND 0.0486771
R450 GND.n87 GND.n86 0.0486771
R451 GND GND.n32 0.0486771
R452 GND.n103 GND.n8 0.0486771
R453 GND.n93 GND.n92 0.0460729
R454 GND.n94 GND.n12 0.0460729
R455 GND.n45 GND.n21 0.0434688
R456 GND.n44 GND.n43 0.0434688
R457 GND.n55 GND.n45 0.0174271
R458 GND.n44 GND.n26 0.0174271
R459 GND.n93 GND.n17 0.0148229
R460 GND.n95 GND.n94 0.0148229
R461 GND GND.n46 0.0122188
R462 GND.n88 GND.n87 0.0122188
R463 GND.n35 GND 0.0122188
R464 GND.n9 GND.n8 0.0122188
R465 GND.n80 GND.n79 0.0114518
R466 GND.n113 GND.n0 0.0114518
R467 GND.n76 GND 0.0109167
R468 GND GND.n115 0.0109167
R469 GND.n73 GND.n70 0.00961458
R470 GND.n107 GND.n3 0.00961458
R471 VDD.n62 VDD.t35 663.062
R472 VDD.n99 VDD.t33 663.062
R473 VDD.n102 VDD.t26 663.062
R474 VDD.n42 VDD.t0 663.062
R475 VDD.n28 VDD.n27 605.481
R476 VDD.n89 VDD.n20 605.481
R477 VDD.n115 VDD.n114 605.481
R478 VDD.n47 VDD.n46 605.481
R479 VDD.n30 VDD.n29 598.965
R480 VDD.n65 VDD.n63 598.965
R481 VDD.n131 VDD.n130 598.965
R482 VDD.n97 VDD.n15 598.965
R483 VDD.n107 VDD.n8 598.965
R484 VDD.n110 VDD.n109 598.965
R485 VDD.n104 VDD.n103 598.965
R486 VDD.n11 VDD.n10 598.965
R487 VDD.n23 VDD.n22 598.965
R488 VDD.n54 VDD.n53 598.965
R489 VDD.n74 VDD.n73 598.965
R490 VDD.n36 VDD.n34 598.965
R491 VDD.n27 VDD.t22 98.5005
R492 VDD.n130 VDD.t25 98.5005
R493 VDD.n20 VDD.t18 98.5005
R494 VDD.n109 VDD.t21 98.5005
R495 VDD.n114 VDD.t31 98.5005
R496 VDD.n22 VDD.t28 98.5005
R497 VDD.n46 VDD.t2 98.5005
R498 VDD.n34 VDD.t3 98.5005
R499 VDD.n29 VDD.t23 63.3219
R500 VDD.n29 VDD.t34 63.3219
R501 VDD.n63 VDD.t17 63.3219
R502 VDD.n63 VDD.t24 63.3219
R503 VDD.n15 VDD.t19 63.3219
R504 VDD.n15 VDD.t32 63.3219
R505 VDD.n8 VDD.t15 63.3219
R506 VDD.n8 VDD.t20 63.3219
R507 VDD.n103 VDD.t27 63.3219
R508 VDD.n103 VDD.t30 63.3219
R509 VDD.n10 VDD.t29 63.3219
R510 VDD.n10 VDD.t10 63.3219
R511 VDD.n53 VDD.t1 63.3219
R512 VDD.n53 VDD.t5 63.3219
R513 VDD.n73 VDD.t4 63.3219
R514 VDD.n73 VDD.t12 63.3219
R515 VDD.n113 VDD.n110 43.9358
R516 VDD.n23 VDD.n19 43.9358
R517 VDD.n83 VDD.n82 34.6358
R518 VDD.n82 VDD.n81 34.6358
R519 VDD.n64 VDD.n1 34.6358
R520 VDD.n128 VDD.n1 34.6358
R521 VDD.n129 VDD.n128 34.6358
R522 VDD.n91 VDD.n90 34.6358
R523 VDD.n91 VDD.n14 34.6358
R524 VDD.n121 VDD.n108 34.6358
R525 VDD.n121 VDD.n120 34.6358
R526 VDD.n120 VDD.n119 34.6358
R527 VDD.n111 VDD.n5 34.6358
R528 VDD.n112 VDD.n111 34.6358
R529 VDD.n21 VDD.n17 34.6358
R530 VDD.n94 VDD.n17 34.6358
R531 VDD.n95 VDD.n94 34.6358
R532 VDD.n52 VDD.n44 34.6358
R533 VDD.n48 VDD.n44 34.6358
R534 VDD.n40 VDD.n37 34.6358
R535 VDD.n41 VDD.n40 34.6358
R536 VDD.n75 VDD.n41 34.6358
R537 VDD.n65 VDD.n64 31.624
R538 VDD.n108 VDD.n107 31.624
R539 VDD.n95 VDD.n11 31.624
R540 VDD.n75 VDD.n74 31.624
R541 VDD.n89 VDD.n19 30.7593
R542 VDD.n83 VDD.n28 28.9887
R543 VDD.n90 VDD.n89 28.9887
R544 VDD.n115 VDD.n112 28.9887
R545 VDD.n48 VDD.n47 28.9887
R546 VDD.n27 VDD.t13 27.9557
R547 VDD.n130 VDD.t14 27.9557
R548 VDD.n20 VDD.t8 27.9557
R549 VDD.n109 VDD.t9 27.9557
R550 VDD.n114 VDD.t11 27.9557
R551 VDD.n22 VDD.t7 27.9557
R552 VDD.n46 VDD.t16 27.9557
R553 VDD.n34 VDD.t6 27.9557
R554 VDD.n61 VDD.n30 27.1064
R555 VDD.n98 VDD.n97 27.1064
R556 VDD.n105 VDD.n104 27.1064
R557 VDD.n55 VDD.n54 27.1064
R558 VDD.n66 VDD.n62 25.6005
R559 VDD.n99 VDD.n7 25.6005
R560 VDD.n102 VDD.n101 25.6005
R561 VDD.n72 VDD.n42 25.6005
R562 VDD.n62 VDD.n61 18.824
R563 VDD.n99 VDD.n98 18.824
R564 VDD.n105 VDD.n102 18.824
R565 VDD.n55 VDD.n42 18.824
R566 VDD.n81 VDD.n30 17.3181
R567 VDD.n97 VDD.n14 17.3181
R568 VDD.n104 VDD.n5 17.3181
R569 VDD.n54 VDD.n52 17.3181
R570 VDD.n66 VDD.n65 12.8005
R571 VDD.n107 VDD.n7 12.8005
R572 VDD.n101 VDD.n11 12.8005
R573 VDD.n74 VDD.n72 12.8005
R574 VDD.n131 VDD.n129 9.78874
R575 VDD.n119 VDD.n110 9.78874
R576 VDD.n23 VDD.n21 9.78874
R577 VDD.n37 VDD.n36 9.78874
R578 VDD.n38 VDD.n37 9.3005
R579 VDD.n40 VDD.n39 9.3005
R580 VDD.n41 VDD.n32 9.3005
R581 VDD.n76 VDD.n75 9.3005
R582 VDD.n74 VDD.n33 9.3005
R583 VDD.n72 VDD.n71 9.3005
R584 VDD.n57 VDD.n42 9.3005
R585 VDD.n56 VDD.n55 9.3005
R586 VDD.n54 VDD.n43 9.3005
R587 VDD.n52 VDD.n51 9.3005
R588 VDD.n50 VDD.n44 9.3005
R589 VDD.n49 VDD.n48 9.3005
R590 VDD.n88 VDD.n23 9.3005
R591 VDD.n21 VDD.n18 9.3005
R592 VDD.n92 VDD.n17 9.3005
R593 VDD.n94 VDD.n93 9.3005
R594 VDD.n96 VDD.n95 9.3005
R595 VDD.n12 VDD.n11 9.3005
R596 VDD.n101 VDD.n100 9.3005
R597 VDD.n102 VDD.n9 9.3005
R598 VDD.n106 VDD.n105 9.3005
R599 VDD.n104 VDD.n4 9.3005
R600 VDD.n122 VDD.n5 9.3005
R601 VDD.n111 VDD.n6 9.3005
R602 VDD.n118 VDD.n112 9.3005
R603 VDD.n117 VDD.n110 9.3005
R604 VDD.n119 VDD.n118 9.3005
R605 VDD.n120 VDD.n6 9.3005
R606 VDD.n122 VDD.n121 9.3005
R607 VDD.n108 VDD.n4 9.3005
R608 VDD.n107 VDD.n106 9.3005
R609 VDD.n9 VDD.n7 9.3005
R610 VDD.n100 VDD.n99 9.3005
R611 VDD.n98 VDD.n12 9.3005
R612 VDD.n97 VDD.n96 9.3005
R613 VDD.n93 VDD.n14 9.3005
R614 VDD.n92 VDD.n91 9.3005
R615 VDD.n90 VDD.n18 9.3005
R616 VDD.n89 VDD.n88 9.3005
R617 VDD.n129 VDD.n0 9.3005
R618 VDD.n128 VDD.n127 9.3005
R619 VDD.n126 VDD.n1 9.3005
R620 VDD.n64 VDD.n2 9.3005
R621 VDD.n65 VDD.n59 9.3005
R622 VDD.n67 VDD.n66 9.3005
R623 VDD.n62 VDD.n58 9.3005
R624 VDD.n61 VDD.n60 9.3005
R625 VDD.n31 VDD.n30 9.3005
R626 VDD.n81 VDD.n80 9.3005
R627 VDD.n82 VDD.n26 9.3005
R628 VDD.n84 VDD.n83 9.3005
R629 VDD.n78 VDD.n77 8.76203
R630 VDD.n70 VDD.n69 8.76203
R631 VDD.n124 VDD.n3 8.76203
R632 VDD.n86 VDD.n24 8.76203
R633 VDD.n79 VDD.n78 8.76203
R634 VDD.n69 VDD.n68 8.76203
R635 VDD.n125 VDD.n124 8.76203
R636 VDD.n86 VDD.n85 8.76065
R637 VDD.n124 VDD.n123 7.9105
R638 VDD.n69 VDD.n13 7.9105
R639 VDD.n78 VDD.n16 7.9105
R640 VDD.n87 VDD.n86 7.9105
R641 VDD.n36 VDD.n35 7.66318
R642 VDD.n132 VDD.n131 7.65909
R643 VDD.n116 VDD.n115 7.13126
R644 VDD.n28 VDD.n25 7.12606
R645 VDD.n47 VDD.n45 7.12063
R646 VDD VDD.n132 0.159538
R647 VDD.n49 VDD.n45 0.148519
R648 VDD.n132 VDD.n0 0.141672
R649 VDD.n39 VDD.n38 0.120292
R650 VDD.n39 VDD.n32 0.120292
R651 VDD.n76 VDD.n33 0.120292
R652 VDD.n71 VDD.n33 0.120292
R653 VDD.n57 VDD.n56 0.120292
R654 VDD.n56 VDD.n43 0.120292
R655 VDD.n51 VDD.n50 0.120292
R656 VDD.n50 VDD.n49 0.120292
R657 VDD.n84 VDD.n26 0.120292
R658 VDD.n80 VDD.n26 0.120292
R659 VDD.n60 VDD.n31 0.120292
R660 VDD.n60 VDD.n58 0.120292
R661 VDD.n67 VDD.n59 0.120292
R662 VDD.n59 VDD.n2 0.120292
R663 VDD.n127 VDD.n126 0.120292
R664 VDD.n127 VDD.n0 0.120292
R665 VDD.n85 VDD.n25 0.119657
R666 VDD.n35 VDD.n24 0.114149
R667 VDD.n45 VDD 0.11354
R668 VDD.n77 VDD.n32 0.0916458
R669 VDD.n80 VDD.n79 0.0916458
R670 VDD.n71 VDD.n70 0.0864375
R671 VDD.n68 VDD.n58 0.0864375
R672 VDD.n43 VDD.n3 0.0812292
R673 VDD.n125 VDD.n2 0.0812292
R674 VDD.n35 VDD 0.0803852
R675 VDD.n25 VDD 0.0748203
R676 VDD.n92 VDD.n18 0.0603958
R677 VDD.n93 VDD.n92 0.0603958
R678 VDD.n96 VDD.n12 0.0603958
R679 VDD.n100 VDD.n12 0.0603958
R680 VDD.n106 VDD.n9 0.0603958
R681 VDD.n106 VDD.n4 0.0603958
R682 VDD.n122 VDD.n6 0.0603958
R683 VDD.n118 VDD.n6 0.0603958
R684 VDD.n118 VDD.n117 0.0603958
R685 VDD.n88 VDD 0.0486771
R686 VDD.n88 VDD.n87 0.0486771
R687 VDD.n116 VDD.n113 0.0469218
R688 VDD.n93 VDD.n16 0.0460729
R689 VDD.n100 VDD.n13 0.0434688
R690 VDD.n123 VDD.n4 0.0408646
R691 VDD.n51 VDD.n3 0.0395625
R692 VDD.n126 VDD.n125 0.0395625
R693 VDD.n70 VDD.n57 0.0343542
R694 VDD.n68 VDD.n67 0.0343542
R695 VDD.n77 VDD.n76 0.0291458
R696 VDD.n79 VDD.n31 0.0291458
R697 VDD.n38 VDD.n24 0.0239375
R698 VDD.n85 VDD.n84 0.0239375
R699 VDD.n123 VDD.n122 0.0200312
R700 VDD.n13 VDD.n9 0.0174271
R701 VDD.n117 VDD.n116 0.0148846
R702 VDD.n96 VDD.n16 0.0148229
R703 VDD VDD.n19 0.0122188
R704 VDD.n87 VDD.n18 0.0122188
R705 VDD.n113 VDD 0.0109167
R706 CIN.n3 CIN.t0 373.283
R707 CIN.n2 CIN.n0 357.442
R708 CIN.n1 CIN.t1 346.022
R709 CIN.n0 CIN.t5 325.082
R710 CIN.n0 CIN.t2 215.829
R711 CIN.n1 CIN.t4 193.337
R712 CIN.n3 CIN.t3 167.63
R713 CIN.n2 CIN.n1 152
R714 CIN.n4 CIN.n3 152
R715 CIN.n4 CIN.n2 88.4259
R716 CIN CIN.n4 5.3765
R717 B0.n9 B0.t3 384.529
R718 B0.n0 B0.t0 373.283
R719 B0.n4 B0.t2 351.861
R720 B0.n3 B0.t6 297.233
R721 B0.n5 B0.n4 214.362
R722 B0.n0 B0.t4 167.63
R723 B0.n10 B0.n9 157.921
R724 B0.n1 B0.n0 156.571
R725 B0.n9 B0.t7 156.382
R726 B0.n6 B0.n5 152
R727 B0.n4 B0.t1 109.215
R728 B0.n3 B0.t5 102.659
R729 B0.n5 B0.n3 47.4474
R730 B0.n7 B0.n6 10.2702
R731 B0.n6 B0 9.69747
R732 B0 B0.n1 9.37931
R733 B0.n11 B0.n10 9.3005
R734 B0.n10 B0 2.7205
R735 B0.n1 B0 2.59098
R736 B0.n2 B0 1.92014
R737 B0.n2 B0 1.79514
R738 B0.n8 B0 1.40229
R739 B0.n8 B0 0.259429
R740 B0.n7 B0.n2 0.0793043
R741 B0 B0.n7 0.0793043
R742 B0.n11 B0.n8 0.0793043
R743 B0 B0.n11 0.0793043
R744 A0.n3 A0.t5 373.283
R745 A0.n0 A0.t4 347.577
R746 A0.n11 A0.t7 334.723
R747 A0.n7 A0.t6 323.476
R748 A0.n7 A0.t2 217.436
R749 A0.n11 A0.t3 206.19
R750 A0.n0 A0.t0 193.337
R751 A0.n3 A0.t1 167.63
R752 A0.n12 A0.n11 152
R753 A0.n8 A0.n7 152
R754 A0.n4 A0.n3 152
R755 A0.n1 A0.n0 152
R756 A0.n9 A0.n8 17.8338
R757 A0.n1 A0 14.6672
R758 A0.n5 A0.n4 14.4205
R759 A0 A0.n1 13.3793
R760 A0.n13 A0.n12 10.4641
R761 A0.n8 A0 3.29747
R762 A0.n2 A0 3.15229
R763 A0.n4 A0 2.90183
R764 A0.n12 A0 2.13383
R765 A0.n6 A0 1.49157
R766 A0.n6 A0 1.40229
R767 A0.n2 A0 1.38443
R768 A0.n10 A0 0.973714
R769 A0.n10 A0 0.259429
R770 A0.n5 A0.n2 0.0793043
R771 A0 A0.n5 0.0793043
R772 A0.n9 A0.n6 0.0793043
R773 A0 A0.n9 0.0793043
R774 A0.n13 A0.n10 0.0793043
R775 A0 A0.n13 0.0793043
C0 a_114_n1033# x3.VPB 0.11528f
C1 A1 B1 0.9494f
C2 A2 x3.CIN 0.46223f
C3 x3.VPB a_491_n289# 0.11528f
C4 a_114_n1033# x4.CIN 0.18897f
C5 VDD x4.VPB 0.18959f
C6 VDD A2 0.10911f
C7 GND x3.CIN 0.26073f
C8 a_491_n289# x2.CIN 0.25128f
C9 a_491_n1569# COUT 0.14389f
C10 GND a_776_n1185# 0.15638f
C11 B0 a_114_247# 0.17223f
C12 CIN a_114_247# 0.25565f
C13 A0 B0 0.95348f
C14 A0 CIN 0.49561f
C15 GND VDD 9.7725f
C16 a_420_n819# VDD 0.15924f
C17 VDD a_545_n1825# 0.1559f
C18 GND A2 0.18164f
C19 A1 a_491_n289# 0.7538f
C20 VDD B3 0.33815f
C21 x4.VPB B3 0.34839f
C22 a_114_n1033# B2 0.17144f
C23 a_491_n1569# VDD 0.24213f
C24 x3.VPB x3.CIN 0.28673f
C25 a_491_n289# B1 0.17144f
C26 a_491_n1569# x4.VPB 0.10634f
C27 a_908_n1825# VDD 0.15914f
C28 VDD a_420_461# 0.15831f
C29 A1 a_152_n571# 0.16271f
C30 a_114_247# x1.VPB 0.10634f
C31 x3.VPB VDD 0.45507f
C32 GND a_908_n1459# 0.14958f
C33 GND B3 0.1076f
C34 A0 x1.VPB 0.27928f
C35 a_152_n1851# A3 0.16271f
C36 x3.VPB A2 0.2969f
C37 a_152_n571# S1 0.15243f
C38 VDD x4.CIN 0.29246f
C39 GND a_491_n1569# 0.45765f
C40 VDD x2.CIN 0.2881f
C41 x4.VPB x4.CIN 0.25557f
C42 S2 a_1033_n1185# 0.15232f
C43 VDD a_114_247# 0.22128f
C44 S0 VDD 0.10668f
C45 CIN B0 0.78726f
C46 A0 VDD 0.10256f
C47 a_491_n1569# B3 0.1714f
C48 a_545_n545# VDD 0.15549f
C49 GND x4.CIN 0.57597f
C50 GND x2.CIN 0.57833f
C51 a_1033_95# VDD 0.24325f
C52 A1 VDD 0.10324f
C53 VDD a_776_461# 0.15334f
C54 B2 x3.CIN 0.66869f
C55 GND a_420_n1185# 0.15097f
C56 GND a_114_247# 0.45956f
C57 x4.CIN B3 0.68616f
C58 GND A0 0.18075f
C59 VDD B1 0.3425f
C60 VDD B2 0.35108f
C61 VDD A3 0.102f
C62 a_491_n1569# x4.CIN 0.25192f
C63 x4.VPB A3 0.27928f
C64 A2 B2 0.9494f
C65 A1 GND 0.19564f
C66 GND a_1033_95# 0.22036f
C67 a_1033_n1185# VDD 0.24495f
C68 B0 x1.VPB 0.3492f
C69 CIN x1.VPB 0.26258f
C70 a_1033_n1185# A2 0.16271f
C71 x3.VPB x2.CIN 0.27014f
C72 GND a_545_n1459# 0.15623f
C73 GND B1 0.10771f
C74 GND B2 0.10809f
C75 GND A3 0.19495f
C76 a_114_n1033# x3.CIN 0.22289f
C77 a_491_n289# x3.CIN 0.16797f
C78 a_1033_n1185# GND 0.2185f
C79 a_114_n1033# VDD 0.22643f
C80 B0 VDD 0.34005f
C81 CIN VDD 0.37414f
C82 a_776_n819# VDD 0.15392f
C83 B3 A3 0.9494f
C84 a_491_n289# VDD 0.23817f
C85 a_114_n1033# A2 0.75375f
C86 x2.CIN a_114_247# 0.18403f
C87 A1 x3.VPB 0.2969f
C88 a_491_n1569# A3 0.7538f
C89 a_152_n1851# VDD 0.22632f
C90 a_114_n1033# GND 0.46236f
C91 A1 x2.CIN 0.49201f
C92 A0 a_114_247# 0.75411f
C93 x3.VPB B1 0.37518f
C94 GND B0 0.10327f
C95 GND CIN 0.24913f
C96 x3.VPB B2 0.37514f
C97 a_152_n571# VDD 0.22728f
C98 GND a_545_n179# 0.15637f
C99 GND a_491_n289# 0.45584f
C100 GND a_908_n179# 0.14964f
C101 VDD COUT 0.13131f
C102 x4.CIN A3 0.49188f
C103 x2.CIN B1 0.68362f
C104 a_1033_95# S0 0.15158f
C105 A0 a_1033_95# 0.16271f
C106 GND a_152_n1851# 0.22678f
C107 VDD x1.VPB 0.18583f
C108 VDD a_908_n545# 0.15891f
C109 GND a_776_95# 0.1563f
C110 a_152_n571# GND 0.22675f
C111 VDD x3.CIN 0.58639f
C112 a_152_n1851# S3 0.15117f
C113 CIN a_420_461# 0.10214f
C114 a_420_95# GND 0.15063f
C115 COUT x4.VNB 0.3494f
C116 S3 x4.VNB 0.3048f
C117 B3 x4.VNB 0.66458f
C118 A3 x4.VNB 0.44938f
C119 S2 x4.VNB 0.30993f
C120 B2 x4.VNB 0.8151f
C121 A2 x4.VNB 0.70077f
C122 S1 x4.VNB 0.29577f
C123 B1 x4.VNB 0.63962f
C124 A1 x4.VNB 0.42118f
C125 S0 x4.VNB 0.33195f
C126 GND x4.VNB 1.91001f
C127 VDD x4.VNB 2.63205f
C128 CIN x4.VNB 1.49277f
C129 B0 x4.VNB 0.87995f
C130 A0 x4.VNB 0.74381f
C131 a_491_n1569# x4.VNB 0.20637f
C132 x4.CIN x4.VNB 0.4618f
C133 a_114_n1033# x4.VNB 0.1956f
C134 x3.CIN x4.VNB 0.39882f
C135 a_491_n289# x4.VNB 0.1956f
C136 x2.CIN x4.VNB 0.4192f
C137 a_114_247# x4.VNB 0.20637f
C138 x4.VPB x4.VNB 1.49072f
C139 x3.VPB x4.VNB 3.07433f
C140 x1.VPB x4.VNB 1.49072f
C141 A0.t4 x4.VNB 0.10371f
C142 A0.n0 x4.VNB 0.2023f
C143 A0.n2 x4.VNB 0.40887f
C144 A0.t5 x4.VNB 0.1102f
C145 A0.n3 x4.VNB 0.20201f
C146 A0.n6 x4.VNB 0.26741f
C147 A0.n7 x4.VNB 0.20248f
C148 A0.n10 x4.VNB 0.12441f
C149 A0.t7 x4.VNB 0.10047f
C150 A0.n11 x4.VNB 0.20241f
C151 B0.t0 x4.VNB 0.10268f
C152 B0.n0 x4.VNB 0.19024f
C153 B0.n1 x4.VNB 0.1177f
C154 B0.n2 x4.VNB 0.31507f
C155 B0.n3 x4.VNB 0.17727f
C156 B0.t2 x4.VNB 0.10484f
C157 B0.n4 x4.VNB 0.18689f
C158 B0.n5 x4.VNB 0.1437f
C159 B0.n8 x4.VNB 0.15031f
C160 B0.t3 x4.VNB 0.10533f
C161 B0.n9 x4.VNB 0.19202f
C162 B0.n10 x4.VNB 0.15672f
C163 CIN.n0 x4.VNB 0.34404f
C164 CIN.n1 x4.VNB 0.16313f
C165 CIN.n2 x4.VNB 0.5996f
C166 CIN.n3 x4.VNB 0.16278f
C167 CIN.n4 x4.VNB 0.1272f
C168 VDD.n0 x4.VNB 0.10111f
C169 VDD.n3 x4.VNB 0.11399f
C170 VDD.n4 x4.VNB 0.14698f
C171 VDD.n6 x4.VNB 0.17562f
C172 VDD.n9 x4.VNB 0.11262f
C173 VDD.n12 x4.VNB 0.17562f
C174 VDD.n13 x4.VNB 0.11126f
C175 VDD.n16 x4.VNB 0.11126f
C176 VDD.n18 x4.VNB 0.10499f
C177 VDD.n19 x4.VNB 0.14707f
C178 VDD.n24 x4.VNB 0.12474f
C179 VDD.n49 x4.VNB 0.10455f
C180 VDD.n68 x4.VNB 0.11399f
C181 VDD.n69 x4.VNB 1.73029f
C182 VDD.n70 x4.VNB 0.11399f
C183 VDD.n77 x4.VNB 0.11399f
C184 VDD.n78 x4.VNB 1.73029f
C185 VDD.n79 x4.VNB 0.11399f
C186 VDD.n85 x4.VNB 0.12751f
C187 VDD.n86 x4.VNB 1.73029f
C188 VDD.n87 x4.VNB 0.11126f
C189 VDD.n88 x4.VNB 0.14126f
C190 VDD.n92 x4.VNB 0.17562f
C191 VDD.n93 x4.VNB 0.15462f
C192 VDD.n96 x4.VNB 0.10881f
C193 VDD.n100 x4.VNB 0.1508f
C194 VDD.n106 x4.VNB 0.17562f
C195 VDD.n113 x4.VNB 0.14516f
C196 VDD.n117 x4.VNB 0.17562f
C197 VDD.n118 x4.VNB 0.17562f
C198 VDD.n122 x4.VNB 0.11644f
C199 VDD.n123 x4.VNB 0.11126f
C200 VDD.n124 x4.VNB 1.73029f
C201 VDD.n125 x4.VNB 0.11399f
C202 VDD.n132 x4.VNB 0.10854f
C203 GND.n3 x4.VNB 1.00696f
C204 GND.n5 x4.VNB 0.17551f
C205 GND.n8 x4.VNB 1.00696f
C206 GND.n9 x4.VNB 0.10492f
C207 GND.n12 x4.VNB 0.15453f
C208 GND.n15 x4.VNB 0.17551f
C209 GND.n17 x4.VNB 0.10874f
C210 GND.n19 x4.VNB 0.17551f
C211 GND.n21 x4.VNB 0.15071f
C212 GND.n25 x4.VNB 0.17551f
C213 GND.n26 x4.VNB 0.11256f
C214 GND.n32 x4.VNB 0.15834f
C215 GND.n35 x4.VNB 0.14699f
C216 GND.n39 x4.VNB 0.17551f
C217 GND.n43 x4.VNB 0.15071f
C218 GND.n44 x4.VNB 1.00696f
C219 GND.n45 x4.VNB 1.00696f
C220 GND.n46 x4.VNB 0.14699f
C221 GND.n49 x4.VNB 0.15834f
C222 GND.n55 x4.VNB 0.11256f
C223 GND.n59 x4.VNB 0.17551f
C224 GND.n70 x4.VNB 0.10111f
C225 GND.n73 x4.VNB 1.00696f
C226 GND.n76 x4.VNB 0.14508f
C227 GND.n80 x4.VNB 0.17551f
C228 GND.n81 x4.VNB 0.16216f
C229 GND.n85 x4.VNB 0.17551f
C230 GND.n86 x4.VNB 0.15834f
C231 GND.n87 x4.VNB 1.00696f
C232 GND.n88 x4.VNB 0.10492f
C233 GND.n92 x4.VNB 0.15453f
C234 GND.n93 x4.VNB 1.00696f
C235 GND.n94 x4.VNB 1.00696f
C236 GND.n95 x4.VNB 0.10874f
C237 GND.n99 x4.VNB 0.17551f
C238 GND.n103 x4.VNB 0.15834f
C239 GND.n107 x4.VNB 0.10111f
C240 GND.n112 x4.VNB 0.16216f
C241 GND.n113 x4.VNB 0.17551f
C242 GND.n115 x4.VNB 0.14508f
C243 A1.t3 x4.VNB 0.10459f
C244 A1.n0 x4.VNB 0.20615f
C245 A1.n1 x4.VNB 0.10287f
C246 A1.n3 x4.VNB 0.16113f
C247 A1.t2 x4.VNB 0.11114f
C248 A1.n4 x4.VNB 0.20588f
C249 A1.n5 x4.VNB 0.11308f
C250 A1.n7 x4.VNB 0.30533f
C251 A1.n8 x4.VNB 0.20799f
C252 A1.n9 x4.VNB 0.12322f
C253 A1.n11 x4.VNB 0.41233f
C254 A1.t0 x4.VNB 0.10132f
C255 A1.n12 x4.VNB 0.20604f
C256 A1.n14 x4.VNB 0.13778f
C257 B1.t7 x4.VNB 0.10227f
C258 B1.n0 x4.VNB 0.18746f
C259 B1.n3 x4.VNB 0.18109f
C260 B1.t5 x4.VNB 0.10442f
C261 B1.n4 x4.VNB 0.18613f
C262 B1.n5 x4.VNB 0.17649f
C263 B1.n6 x4.VNB 0.14312f
C264 B1.n9 x4.VNB 0.31379f
C265 B1.t4 x4.VNB 0.10491f
C266 B1.n10 x4.VNB 0.19108f
C267 B1.n11 x4.VNB 0.15471f
C268 B1.n12 x4.VNB 0.16452f
C269 A2.t4 x4.VNB 0.10432f
C270 A2.n0 x4.VNB 0.20349f
C271 A2.n2 x4.VNB 0.41127f
C272 A2.t5 x4.VNB 0.11085f
C273 A2.n3 x4.VNB 0.20319f
C274 A2.n6 x4.VNB 0.26898f
C275 A2.n7 x4.VNB 0.20367f
C276 A2.n10 x4.VNB 0.12514f
C277 A2.t7 x4.VNB 0.10106f
C278 A2.n11 x4.VNB 0.2036f
C279 B2.t0 x4.VNB 0.10095f
C280 B2.n0 x4.VNB 0.18701f
C281 B2.n1 x4.VNB 0.1157f
C282 B2.n2 x4.VNB 0.30973f
C283 B2.n3 x4.VNB 0.17426f
C284 B2.t2 x4.VNB 0.10307f
C285 B2.n4 x4.VNB 0.18372f
C286 B2.n5 x4.VNB 0.14127f
C287 B2.n8 x4.VNB 0.14776f
C288 B2.t3 x4.VNB 0.10355f
C289 B2.n9 x4.VNB 0.18876f
C290 B2.n10 x4.VNB 0.15406f
C291 A3.t3 x4.VNB 0.10311f
C292 A3.n0 x4.VNB 0.20322f
C293 A3.n1 x4.VNB 0.10141f
C294 A3.n3 x4.VNB 0.15884f
C295 A3.t2 x4.VNB 0.10956f
C296 A3.n4 x4.VNB 0.20296f
C297 A3.n5 x4.VNB 0.11148f
C298 A3.n7 x4.VNB 0.30101f
C299 A3.n8 x4.VNB 0.20504f
C300 A3.n9 x4.VNB 0.12148f
C301 A3.n11 x4.VNB 0.40648f
C302 A3.n12 x4.VNB 0.20312f
C303 A3.n14 x4.VNB 0.13582f
C304 B3.t7 x4.VNB 0.10042f
C305 B3.n0 x4.VNB 0.18408f
C306 B3.n3 x4.VNB 0.17782f
C307 B3.t5 x4.VNB 0.10253f
C308 B3.n4 x4.VNB 0.18277f
C309 B3.n5 x4.VNB 0.1733f
C310 B3.n6 x4.VNB 0.14053f
C311 B3.n9 x4.VNB 0.30812f
C312 B3.t4 x4.VNB 0.10301f
C313 B3.n10 x4.VNB 0.18763f
C314 B3.n11 x4.VNB 0.15191f
C315 B3.n12 x4.VNB 0.16154f
.ends
