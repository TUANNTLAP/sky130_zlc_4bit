* NGSPICE file created from new_adder_4bit.ext - technology: sky130A

.subckt new_adder_4bit A0 A2 B0 B2 CIN GND S1 S3 VDD S0 A1 B1 S2 COUT B3 A3
X0 VDD.t26 a_114_247# x2.CIN VDD.t25 sky130_fd_pr__pfet_01v8_hvt ad=0.14785 pd=1.345 as=0.26 ps=2.52 w=1 l=0.15
X1 a_246_95# A0.t3 GND.t75 GND.t74 sky130_fd_pr__nfet_01v8 ad=0.063 pd=0.72 as=0.10235 ps=0.995 w=0.42 l=0.15
X2 VDD.t37 A2.t4 a_1201_n819# VDD.t36 sky130_fd_pr__pfet_01v8_hvt ad=0.14785 pd=1.345 as=0.0693 ps=0.75 w=0.42 l=0.15
X3 GND.t62 B1.t5 a_908_n179# GND.t61 sky130_fd_pr__nfet_01v8 ad=0.0567 pd=0.69 as=0.1092 ps=1.36 w=0.42 l=0.15
X4 GND.t34 CIN.t1 a_776_95# GND.t33 sky130_fd_pr__nfet_01v8 ad=0.0567 pd=0.69 as=0.0567 ps=0.69 w=0.42 l=0.15
X5 S0.t0 a_1033_95# VDD.t29 VDD.t28 sky130_fd_pr__pfet_01v8_hvt ad=0.26 pd=2.52 as=0.14785 ps=1.345 w=1 l=0.15
X6 a_1033_n1185# a_114_n1033# a_776_n1185# GND.t19 sky130_fd_pr__nfet_01v8 ad=0.0693 pd=0.75 as=0.06195 ps=0.715 w=0.42 l=0.15
X7 a_776_n819# A2.t5 VDD.t39 VDD.t38 sky130_fd_pr__pfet_01v8_hvt ad=0.06195 pd=0.715 as=0.0567 ps=0.69 w=0.42 l=0.15
X8 a_377_n1459# B3.t7 a_281_n1459# GND.t64 sky130_fd_pr__nfet_01v8 ad=0.0441 pd=0.63 as=0.0693 ps=0.75 w=0.42 l=0.15
X9 a_1129_n1185# x3.CIN a_1033_n1185# GND.t11 sky130_fd_pr__nfet_01v8 ad=0.0441 pd=0.63 as=0.0693 ps=0.75 w=0.42 l=0.15
X10 a_152_n1851# x4.CIN a_377_n1459# GND.t4 sky130_fd_pr__nfet_01v8 ad=0.0693 pd=0.75 as=0.0441 ps=0.63 w=0.42 l=0.15
X11 a_1129_n819# x3.CIN a_1033_n1185# VDD.t11 sky130_fd_pr__pfet_01v8_hvt ad=0.0441 pd=0.63 as=0.0693 ps=0.75 w=0.42 l=0.15
X12 GND.t68 B3.t5 a_908_n1459# GND.t67 sky130_fd_pr__nfet_01v8 ad=0.0567 pd=0.69 as=0.1092 ps=1.36 w=0.42 l=0.15
X13 a_545_n179# x2.CIN GND.t2 GND.t1 sky130_fd_pr__nfet_01v8 ad=0.0567 pd=0.69 as=0.0567 ps=0.69 w=0.42 l=0.15
X14 a_908_n1459# A3.t5 GND.t87 GND.t86 sky130_fd_pr__nfet_01v8 ad=0.0567 pd=0.69 as=0.0567 ps=0.69 w=0.42 l=0.15
X15 a_776_n819# B2.t5 VDD.t82 VDD.t81 sky130_fd_pr__pfet_01v8_hvt ad=0.0567 pd=0.69 as=0.1092 ps=1.36 w=0.42 l=0.15
X16 a_420_n819# x3.CIN a_114_n1033# VDD.t8 sky130_fd_pr__pfet_01v8_hvt ad=0.0567 pd=0.69 as=0.0567 ps=0.69 w=0.42 l=0.15
X17 a_1129_95# CIN.t0 a_1033_95# GND.t35 sky130_fd_pr__nfet_01v8 ad=0.0441 pd=0.63 as=0.0693 ps=0.75 w=0.42 l=0.15
X18 a_545_n1459# a_491_n1569# a_152_n1851# GND.t20 sky130_fd_pr__nfet_01v8 ad=0.06195 pd=0.715 as=0.0693 ps=0.75 w=0.42 l=0.15
X19 x3.CIN a_491_n289# GND.t14 GND.t13 sky130_fd_pr__nfet_01v8 ad=0.169 pd=1.82 as=0.10235 ps=0.995 w=0.65 l=0.15
X20 GND.t77 A0.t0 a_1201_95# GND.t76 sky130_fd_pr__nfet_01v8 ad=0.10235 pd=0.995 as=0.0693 ps=0.75 w=0.42 l=0.15
X21 a_114_247# B0.t7 a_246_461# VDD.t44 sky130_fd_pr__pfet_01v8_hvt ad=0.0567 pd=0.69 as=0.063 ps=0.72 w=0.42 l=0.15
X22 GND.t39 A2.t0 a_1201_n1185# GND.t38 sky130_fd_pr__nfet_01v8 ad=0.10235 pd=0.995 as=0.0693 ps=0.75 w=0.42 l=0.15
X23 a_1201_461# B0.t4 a_1129_461# VDD.t49 sky130_fd_pr__pfet_01v8_hvt ad=0.0693 pd=0.75 as=0.0441 ps=0.63 w=0.42 l=0.15
X24 GND.t26 a_114_247# x2.CIN GND.t25 sky130_fd_pr__nfet_01v8 ad=0.10235 pd=0.995 as=0.169 ps=1.82 w=0.65 l=0.15
X25 VDD.t62 B1.t1 a_908_n545# VDD.t61 sky130_fd_pr__pfet_01v8_hvt ad=0.0567 pd=0.69 as=0.1092 ps=1.36 w=0.42 l=0.15
X26 a_545_n179# a_491_n289# a_152_n571# GND.t12 sky130_fd_pr__nfet_01v8 ad=0.06195 pd=0.715 as=0.0693 ps=0.75 w=0.42 l=0.15
X27 VDD.t77 A0.t4 a_1201_461# VDD.t76 sky130_fd_pr__pfet_01v8_hvt ad=0.14785 pd=1.345 as=0.0693 ps=0.75 w=0.42 l=0.15
X28 a_246_n819# A2.t7 VDD.t43 VDD.t42 sky130_fd_pr__pfet_01v8_hvt ad=0.063 pd=0.72 as=0.14785 ps=1.345 w=0.42 l=0.15
X29 a_246_461# A0.t7 VDD.t75 VDD.t74 sky130_fd_pr__pfet_01v8_hvt ad=0.063 pd=0.72 as=0.14785 ps=1.345 w=0.42 l=0.15
X30 a_377_n1825# B3.t3 a_281_n1825# VDD.t64 sky130_fd_pr__pfet_01v8_hvt ad=0.0441 pd=0.63 as=0.0693 ps=0.75 w=0.42 l=0.15
X31 a_1242_n179# B1.t4 a_491_n289# GND.t63 sky130_fd_pr__nfet_01v8 ad=0.063 pd=0.72 as=0.0567 ps=0.69 w=0.42 l=0.15
X32 a_776_95# B0.t1 GND.t48 GND.t47 sky130_fd_pr__nfet_01v8 ad=0.0567 pd=0.69 as=0.1092 ps=1.36 w=0.42 l=0.15
X33 a_1242_n1459# B3.t4 a_491_n1569# GND.t69 sky130_fd_pr__nfet_01v8 ad=0.063 pd=0.72 as=0.0567 ps=0.69 w=0.42 l=0.15
X34 a_152_n1851# x4.CIN a_377_n1825# VDD.t4 sky130_fd_pr__pfet_01v8_hvt ad=0.0693 pd=0.75 as=0.0441 ps=0.63 w=0.42 l=0.15
X35 a_776_95# A0.t1 GND.t73 GND.t72 sky130_fd_pr__nfet_01v8 ad=0.06195 pd=0.715 as=0.0567 ps=0.69 w=0.42 l=0.15
X36 a_114_n1033# B2.t7 a_246_n819# VDD.t78 sky130_fd_pr__pfet_01v8_hvt ad=0.0567 pd=0.69 as=0.063 ps=0.72 w=0.42 l=0.15
X37 a_377_n179# B1.t7 a_281_n179# GND.t58 sky130_fd_pr__nfet_01v8 ad=0.0441 pd=0.63 as=0.0693 ps=0.75 w=0.42 l=0.15
X38 VDD.t68 B3.t1 a_908_n1825# VDD.t67 sky130_fd_pr__pfet_01v8_hvt ad=0.0567 pd=0.69 as=0.1092 ps=1.36 w=0.42 l=0.15
X39 a_545_n545# x2.CIN VDD.t2 VDD.t1 sky130_fd_pr__pfet_01v8_hvt ad=0.0567 pd=0.69 as=0.0567 ps=0.69 w=0.42 l=0.15
X40 a_908_n1825# A3.t1 VDD.t89 VDD.t88 sky130_fd_pr__pfet_01v8_hvt ad=0.0567 pd=0.69 as=0.0567 ps=0.69 w=0.42 l=0.15
X41 GND.t51 A1.t4 a_1242_n179# GND.t50 sky130_fd_pr__nfet_01v8 ad=0.10235 pd=0.995 as=0.063 ps=0.72 w=0.42 l=0.15
X42 a_491_n1569# x4.CIN a_908_n1459# GND.t7 sky130_fd_pr__nfet_01v8 ad=0.0567 pd=0.69 as=0.0567 ps=0.69 w=0.42 l=0.15
X43 a_1033_n1185# a_114_n1033# a_776_n819# VDD.t19 sky130_fd_pr__pfet_01v8_hvt ad=0.0693 pd=0.75 as=0.06195 ps=0.715 w=0.42 l=0.15
X44 a_908_n179# A1.t5 GND.t53 GND.t52 sky130_fd_pr__nfet_01v8 ad=0.0567 pd=0.69 as=0.0567 ps=0.69 w=0.42 l=0.15
X45 GND.t24 a_152_n1851# S3.t0 GND.t23 sky130_fd_pr__nfet_01v8 ad=0.10235 pd=0.995 as=0.169 ps=1.82 w=0.65 l=0.15
X46 a_420_95# CIN.t2 a_114_247# GND.t32 sky130_fd_pr__nfet_01v8 ad=0.0567 pd=0.69 as=0.0567 ps=0.69 w=0.42 l=0.15
X47 a_545_n1825# a_491_n1569# a_152_n1851# VDD.t20 sky130_fd_pr__pfet_01v8_hvt ad=0.06195 pd=0.715 as=0.0693 ps=0.75 w=0.42 l=0.15
X48 a_545_n545# a_491_n289# a_152_n571# VDD.t12 sky130_fd_pr__pfet_01v8_hvt ad=0.06195 pd=0.715 as=0.0693 ps=0.75 w=0.42 l=0.15
X49 S2.t0 a_1033_n1185# GND.t16 GND.t15 sky130_fd_pr__nfet_01v8 ad=0.169 pd=1.82 as=0.10235 ps=0.995 w=0.65 l=0.15
X50 a_1129_461# CIN.t3 a_1033_95# VDD.t35 sky130_fd_pr__pfet_01v8_hvt ad=0.0441 pd=0.63 as=0.0693 ps=0.75 w=0.42 l=0.15
X51 GND.t91 A3.t4 a_1242_n1459# GND.t90 sky130_fd_pr__nfet_01v8 ad=0.10235 pd=0.995 as=0.063 ps=0.72 w=0.42 l=0.15
X52 a_152_n571# x2.CIN a_377_n179# GND.t0 sky130_fd_pr__nfet_01v8 ad=0.0693 pd=0.75 as=0.0441 ps=0.63 w=0.42 l=0.15
X53 a_1242_n545# B1.t0 a_491_n289# VDD.t63 sky130_fd_pr__pfet_01v8_hvt ad=0.063 pd=0.72 as=0.0567 ps=0.69 w=0.42 l=0.15
X54 GND.t66 B3.t6 a_545_n1459# GND.t65 sky130_fd_pr__nfet_01v8 ad=0.1092 pd=1.36 as=0.0567 ps=0.69 w=0.42 l=0.15
X55 a_1242_n1825# B3.t0 a_491_n1569# VDD.t69 sky130_fd_pr__pfet_01v8_hvt ad=0.063 pd=0.72 as=0.0567 ps=0.69 w=0.42 l=0.15
X56 VDD.t41 A2.t6 a_420_n819# VDD.t40 sky130_fd_pr__pfet_01v8_hvt ad=0.0567 pd=0.69 as=0.0567 ps=0.69 w=0.42 l=0.15
X57 a_377_n545# B1.t3 a_281_n545# VDD.t58 sky130_fd_pr__pfet_01v8_hvt ad=0.0441 pd=0.63 as=0.0693 ps=0.75 w=0.42 l=0.15
X58 COUT.t1 a_491_n1569# GND.t22 GND.t21 sky130_fd_pr__nfet_01v8 ad=0.169 pd=1.82 as=0.10235 ps=0.995 w=0.65 l=0.15
X59 a_491_n1569# x4.CIN a_908_n1825# VDD.t7 sky130_fd_pr__pfet_01v8_hvt ad=0.0567 pd=0.69 as=0.0567 ps=0.69 w=0.42 l=0.15
X60 a_545_n1459# x4.CIN GND.t6 GND.t5 sky130_fd_pr__nfet_01v8 ad=0.0567 pd=0.69 as=0.0567 ps=0.69 w=0.42 l=0.15
X61 a_1201_n819# B2.t4 a_1129_n819# VDD.t83 sky130_fd_pr__pfet_01v8_hvt ad=0.0693 pd=0.75 as=0.0441 ps=0.63 w=0.42 l=0.15
X62 VDD.t53 A1.t0 a_1242_n545# VDD.t52 sky130_fd_pr__pfet_01v8_hvt ad=0.14785 pd=1.345 as=0.063 ps=0.72 w=0.42 l=0.15
X63 x3.CIN a_491_n289# VDD.t14 VDD.t13 sky130_fd_pr__pfet_01v8_hvt ad=0.26 pd=2.52 as=0.14785 ps=1.345 w=1 l=0.15
X64 a_908_n545# A1.t1 VDD.t55 VDD.t54 sky130_fd_pr__pfet_01v8_hvt ad=0.0567 pd=0.69 as=0.0567 ps=0.69 w=0.42 l=0.15
X65 GND.t55 A1.t6 a_545_n179# GND.t54 sky130_fd_pr__nfet_01v8 ad=0.0567 pd=0.69 as=0.06195 ps=0.715 w=0.42 l=0.15
X66 a_114_247# B0.t3 a_246_95# GND.t44 sky130_fd_pr__nfet_01v8 ad=0.0567 pd=0.69 as=0.063 ps=0.72 w=0.42 l=0.15
X67 GND.t10 x3.CIN a_776_n1185# GND.t9 sky130_fd_pr__nfet_01v8 ad=0.0567 pd=0.69 as=0.0567 ps=0.69 w=0.42 l=0.15
X68 a_420_n1185# x3.CIN a_114_n1033# GND.t8 sky130_fd_pr__nfet_01v8 ad=0.0567 pd=0.69 as=0.0567 ps=0.69 w=0.42 l=0.15
X69 VDD.t85 A3.t0 a_1242_n1825# VDD.t84 sky130_fd_pr__pfet_01v8_hvt ad=0.14785 pd=1.345 as=0.063 ps=0.72 w=0.42 l=0.15
X70 GND.t18 a_114_n1033# x4.CIN GND.t17 sky130_fd_pr__nfet_01v8 ad=0.10235 pd=0.995 as=0.169 ps=1.82 w=0.65 l=0.15
X71 a_152_n571# x2.CIN a_377_n545# VDD.t0 sky130_fd_pr__pfet_01v8_hvt ad=0.0693 pd=0.75 as=0.0441 ps=0.63 w=0.42 l=0.15
X72 a_776_n1185# B2.t1 GND.t82 GND.t81 sky130_fd_pr__nfet_01v8 ad=0.0567 pd=0.69 as=0.1092 ps=1.36 w=0.42 l=0.15
X73 GND.t31 a_152_n571# S1.t1 GND.t30 sky130_fd_pr__nfet_01v8 ad=0.10235 pd=0.995 as=0.169 ps=1.82 w=0.65 l=0.15
X74 GND.t71 A0.t2 a_420_95# GND.t70 sky130_fd_pr__nfet_01v8 ad=0.0567 pd=0.69 as=0.0567 ps=0.69 w=0.42 l=0.15
X75 VDD.t66 B3.t2 a_545_n1825# VDD.t65 sky130_fd_pr__pfet_01v8_hvt ad=0.1092 pd=1.36 as=0.0567 ps=0.69 w=0.42 l=0.15
X76 GND.t85 A3.t6 a_545_n1459# GND.t84 sky130_fd_pr__nfet_01v8 ad=0.0567 pd=0.69 as=0.06195 ps=0.715 w=0.42 l=0.15
X77 a_1033_95# a_114_247# a_776_461# VDD.t27 sky130_fd_pr__pfet_01v8_hvt ad=0.0693 pd=0.75 as=0.06195 ps=0.715 w=0.42 l=0.15
X78 a_491_n289# x2.CIN a_908_n179# GND.t3 sky130_fd_pr__nfet_01v8 ad=0.0567 pd=0.69 as=0.0567 ps=0.69 w=0.42 l=0.15
X79 a_420_461# B0.t6 VDD.t46 VDD.t45 sky130_fd_pr__pfet_01v8_hvt ad=0.1092 pd=1.36 as=0.0567 ps=0.69 w=0.42 l=0.15
X80 VDD.t24 a_152_n1851# S3.t1 VDD.t23 sky130_fd_pr__pfet_01v8_hvt ad=0.14785 pd=1.345 as=0.26 ps=2.52 w=1 l=0.15
X81 a_545_n1825# x4.CIN VDD.t6 VDD.t5 sky130_fd_pr__pfet_01v8_hvt ad=0.0567 pd=0.69 as=0.0567 ps=0.69 w=0.42 l=0.15
X82 a_281_n1459# A3.t7 GND.t89 GND.t88 sky130_fd_pr__nfet_01v8 ad=0.0693 pd=0.75 as=0.10235 ps=0.995 w=0.42 l=0.15
X83 GND.t60 B1.t6 a_545_n179# GND.t59 sky130_fd_pr__nfet_01v8 ad=0.1092 pd=1.36 as=0.0567 ps=0.69 w=0.42 l=0.15
X84 VDD.t10 x3.CIN a_776_n819# VDD.t9 sky130_fd_pr__pfet_01v8_hvt ad=0.0567 pd=0.69 as=0.0567 ps=0.69 w=0.42 l=0.15
X85 VDD.t57 A1.t2 a_545_n545# VDD.t56 sky130_fd_pr__pfet_01v8_hvt ad=0.0567 pd=0.69 as=0.06195 ps=0.715 w=0.42 l=0.15
X86 VDD.t73 A0.t6 a_420_461# VDD.t72 sky130_fd_pr__pfet_01v8_hvt ad=0.0567 pd=0.69 as=0.0567 ps=0.69 w=0.42 l=0.15
X87 S2.t1 a_1033_n1185# VDD.t16 VDD.t15 sky130_fd_pr__pfet_01v8_hvt ad=0.26 pd=2.52 as=0.14785 ps=1.345 w=1 l=0.15
X88 GND.t41 A2.t2 a_420_n1185# GND.t40 sky130_fd_pr__nfet_01v8 ad=0.0567 pd=0.69 as=0.0567 ps=0.69 w=0.42 l=0.15
X89 a_281_n179# A1.t7 GND.t57 GND.t56 sky130_fd_pr__nfet_01v8 ad=0.0693 pd=0.75 as=0.10235 ps=0.995 w=0.42 l=0.15
X90 a_776_n1185# A2.t1 GND.t43 GND.t42 sky130_fd_pr__nfet_01v8 ad=0.06195 pd=0.715 as=0.0567 ps=0.69 w=0.42 l=0.15
X91 a_1033_95# a_114_247# a_776_95# GND.t27 sky130_fd_pr__nfet_01v8 ad=0.0693 pd=0.75 as=0.06195 ps=0.715 w=0.42 l=0.15
X92 a_776_461# A0.t5 VDD.t71 VDD.t70 sky130_fd_pr__pfet_01v8_hvt ad=0.06195 pd=0.715 as=0.0567 ps=0.69 w=0.42 l=0.15
X93 a_420_n819# B2.t6 VDD.t80 VDD.t79 sky130_fd_pr__pfet_01v8_hvt ad=0.1092 pd=1.36 as=0.0567 ps=0.69 w=0.42 l=0.15
X94 COUT.t0 a_491_n1569# VDD.t22 VDD.t21 sky130_fd_pr__pfet_01v8_hvt ad=0.26 pd=2.52 as=0.14785 ps=1.345 w=1 l=0.15
X95 a_246_n1185# A2.t3 GND.t37 GND.t36 sky130_fd_pr__nfet_01v8 ad=0.063 pd=0.72 as=0.10235 ps=0.995 w=0.42 l=0.15
X96 a_420_461# CIN.t5 a_114_247# VDD.t32 sky130_fd_pr__pfet_01v8_hvt ad=0.0567 pd=0.69 as=0.0567 ps=0.69 w=0.42 l=0.15
X97 VDD.t87 A3.t2 a_545_n1825# VDD.t86 sky130_fd_pr__pfet_01v8_hvt ad=0.0567 pd=0.69 as=0.06195 ps=0.715 w=0.42 l=0.15
X98 a_1201_95# B0.t0 a_1129_95# GND.t49 sky130_fd_pr__nfet_01v8 ad=0.0693 pd=0.75 as=0.0441 ps=0.63 w=0.42 l=0.15
X99 a_1201_n1185# B2.t0 a_1129_n1185# GND.t83 sky130_fd_pr__nfet_01v8 ad=0.0693 pd=0.75 as=0.0441 ps=0.63 w=0.42 l=0.15
X100 a_491_n289# x2.CIN a_908_n545# VDD.t3 sky130_fd_pr__pfet_01v8_hvt ad=0.0567 pd=0.69 as=0.0567 ps=0.69 w=0.42 l=0.15
X101 VDD.t34 CIN.t4 a_776_461# VDD.t33 sky130_fd_pr__pfet_01v8_hvt ad=0.0567 pd=0.69 as=0.0567 ps=0.69 w=0.42 l=0.15
X102 a_420_95# B0.t2 GND.t46 GND.t45 sky130_fd_pr__nfet_01v8 ad=0.1092 pd=1.36 as=0.0567 ps=0.69 w=0.42 l=0.15
X103 a_281_n1825# A3.t3 VDD.t91 VDD.t90 sky130_fd_pr__pfet_01v8_hvt ad=0.0693 pd=0.75 as=0.14785 ps=1.345 w=0.42 l=0.15
X104 VDD.t60 B1.t2 a_545_n545# VDD.t59 sky130_fd_pr__pfet_01v8_hvt ad=0.1092 pd=1.36 as=0.0567 ps=0.69 w=0.42 l=0.15
X105 VDD.t18 a_114_n1033# x4.CIN VDD.t17 sky130_fd_pr__pfet_01v8_hvt ad=0.14785 pd=1.345 as=0.26 ps=2.52 w=1 l=0.15
X106 VDD.t31 a_152_n571# S1.t0 VDD.t30 sky130_fd_pr__pfet_01v8_hvt ad=0.14785 pd=1.345 as=0.26 ps=2.52 w=1 l=0.15
X107 a_281_n545# A1.t3 VDD.t51 VDD.t50 sky130_fd_pr__pfet_01v8_hvt ad=0.0693 pd=0.75 as=0.14785 ps=1.345 w=0.42 l=0.15
X108 a_114_n1033# B2.t3 a_246_n1185# GND.t78 sky130_fd_pr__nfet_01v8 ad=0.0567 pd=0.69 as=0.063 ps=0.72 w=0.42 l=0.15
X109 a_420_n1185# B2.t2 GND.t80 GND.t79 sky130_fd_pr__nfet_01v8 ad=0.1092 pd=1.36 as=0.0567 ps=0.69 w=0.42 l=0.15
X110 S0.t1 a_1033_95# GND.t29 GND.t28 sky130_fd_pr__nfet_01v8 ad=0.169 pd=1.82 as=0.10235 ps=0.995 w=0.65 l=0.15
X111 a_776_461# B0.t5 VDD.t48 VDD.t47 sky130_fd_pr__pfet_01v8_hvt ad=0.0567 pd=0.69 as=0.1092 ps=1.36 w=0.42 l=0.15
R0 COUT.n2 COUT.t0 782
R1 COUT.t0 COUT.n1 744.115
R2 COUT COUT.t1 211.647
R3 COUT.n1 COUT 73.7552
R4 COUT.n0 COUT 14.2693
R5 COUT COUT.n0 12.3082
R6 COUT.n1 COUT 8.86204
R7 COUT COUT.n2 2.46204
R8 COUT.n2 COUT.n0 1.96973
R9 S3.n4 S3.t1 755.481
R10 S3.t1 S3.n3 755.481
R11 S3 S3.t0 211.043
R12 S3.n2 S3 9.55194
R13 S3.n3 S3 8.1605
R14 S3.n1 S3 8.14595
R15 S3.n0 S3 6.8805
R16 S3.n4 S3 6.2405
R17 S3.n1 S3 5.04292
R18 S3 S3.n0 4.84898
R19 S3 S3.n4 4.6405
R20 S3.n0 S3 4.0005
R21 S3.n3 S3 2.7205
R22 S3 S3.n2 2.5605
R23 S3.n2 S3.n1 1.6005
R24 B3.n10 B3.t4 384.529
R25 B3.n0 B3.t7 373.283
R26 B3.n4 B3.t5 351.861
R27 B3.n5 B3.t1 297.233
R28 B3.n6 B3.n4 214.362
R29 B3.n0 B3.t3 167.63
R30 B3.n11 B3.n10 158.768
R31 B3.n10 B3.t0 156.382
R32 B3.n7 B3.n6 152
R33 B3.n1 B3.n0 152
R34 B3.n4 B3.t6 109.215
R35 B3.n5 B3.t2 102.779
R36 B3.n6 B3.n5 47.4474
R37 B3.n8 B3.n7 11.7894
R38 B3.n2 B3.n1 10.3005
R39 B3.n1 B3 10.2005
R40 B3.n12 B3.n11 9.3005
R41 B3.n7 B3 5.86717
R42 B3.n11 B3 2.50165
R43 B3.n9 B3 2.313
R44 B3 B3.n3 1.79514
R45 B3.n12 B3 1.61055
R46 B3 B3.n9 1.40229
R47 B3.n3 B3 0.259429
R48 B3.n3 B3.n2 0.0793043
R49 B3.n2 B3 0.0793043
R50 B3.n9 B3.n8 0.0793043
R51 B3.n8 B3 0.0793043
R52 B3 B3.n12 0.0793043
R53 A3.n4 A3.t2 373.283
R54 A3.n0 A3.t3 347.577
R55 A3.n12 A3.t0 334.723
R56 A3.n8 A3.t1 323.476
R57 A3.n8 A3.t5 217.436
R58 A3.n12 A3.t4 206.19
R59 A3.n0 A3.t7 193.337
R60 A3.n4 A3.t6 167.63
R61 A3.n9 A3.n8 160.534
R62 A3.n13 A3.n12 159.315
R63 A3.n5 A3.n4 157.12
R64 A3.n1 A3.n0 156
R65 A3.n2 A3.n1 9.3005
R66 A3.n6 A3.n5 9.3005
R67 A3.n10 A3.n9 9.3005
R68 A3.n14 A3.n13 9.3005
R69 A3.n1 A3 4.8005
R70 A3.n13 A3 3.88621
R71 A3.n11 A3 3.563
R72 A3.n9 A3 3.29747
R73 A3.n5 A3 2.90183
R74 A3.n7 A3 1.90229
R75 A3 A3.n7 1.40229
R76 A3 A3.n3 1.38443
R77 A3.n14 A3 1.25118
R78 A3 A3.n11 0.973714
R79 A3.n3 A3 0.259429
R80 A3.n3 A3.n2 0.0793043
R81 A3.n2 A3 0.0793043
R82 A3.n7 A3.n6 0.0793043
R83 A3.n6 A3 0.0793043
R84 A3.n11 A3.n10 0.0793043
R85 A3.n10 A3 0.0793043
R86 A3 A3.n14 0.0793043
R87 S2.t1 S2 758.202
R88 S2.n0 S2.t1 755.481
R89 S2.n3 S2.t0 209.923
R90 S2 S2.n4 11.4429
R91 S2.n2 S2 10.0853
R92 S2.n2 S2 9.76006
R93 S2.n1 S2.n0 8.8005
R94 S2 S2.n3 6.5605
R95 S2.n3 S2 4.3205
R96 S2 S2.n2 3.10353
R97 S2.n4 S2 1.74595
R98 S2 S2.n1 1.55202
R99 S2.n4 S2 1.4405
R100 S2.n1 S2 1.2805
R101 S2.n0 S2 0.8005
R102 B2.n9 B2.t3 384.529
R103 B2.n0 B2.t0 373.283
R104 B2.n4 B2.t2 351.861
R105 B2.n3 B2.t6 297.233
R106 B2.n5 B2.n4 214.362
R107 B2.n0 B2.t4 167.63
R108 B2.n10 B2.n9 157.921
R109 B2.n1 B2.n0 156.571
R110 B2.n9 B2.t7 156.382
R111 B2.n6 B2.n5 152
R112 B2.n4 B2.t1 109.215
R113 B2.n3 B2.t5 102.659
R114 B2.n5 B2.n3 47.4474
R115 B2.n7 B2.n6 10.2702
R116 B2.n6 B2 9.69747
R117 B2 B2.n1 9.37931
R118 B2.n11 B2.n10 9.3005
R119 B2.n10 B2 2.7205
R120 B2.n1 B2 2.59098
R121 B2.n2 B2 1.92014
R122 B2.n2 B2 1.79514
R123 B2.n8 B2 1.40229
R124 B2.n8 B2 0.259429
R125 B2.n7 B2.n2 0.0793043
R126 B2 B2.n7 0.0793043
R127 B2.n11 B2.n8 0.0793043
R128 B2 B2.n11 0.0793043
R129 A2.n3 A2.t5 373.283
R130 A2.n0 A2.t4 347.577
R131 A2.n11 A2.t7 334.723
R132 A2.n7 A2.t6 323.476
R133 A2.n7 A2.t2 217.436
R134 A2.n11 A2.t3 206.19
R135 A2.n0 A2.t0 193.337
R136 A2.n3 A2.t1 167.63
R137 A2.n12 A2.n11 152
R138 A2.n8 A2.n7 152
R139 A2.n4 A2.n3 152
R140 A2.n1 A2.n0 152
R141 A2.n9 A2.n8 17.8338
R142 A2.n1 A2 14.6672
R143 A2.n5 A2.n4 14.4205
R144 A2 A2.n1 13.3793
R145 A2.n13 A2.n12 10.4641
R146 A2.n8 A2 3.29747
R147 A2.n2 A2 3.15229
R148 A2.n4 A2 2.90183
R149 A2.n12 A2 2.13383
R150 A2.n6 A2 1.49157
R151 A2.n6 A2 1.40229
R152 A2.n2 A2 1.38443
R153 A2.n10 A2 0.973714
R154 A2.n10 A2 0.259429
R155 A2.n5 A2.n2 0.0793043
R156 A2 A2.n5 0.0793043
R157 A2.n9 A2.n6 0.0793043
R158 A2 A2.n9 0.0793043
R159 A2.n13 A2.n10 0.0793043
R160 A2 A2.n13 0.0793043
R161 S1.n3 S1.t0 755.481
R162 S1.t0 S1.n2 755.481
R163 S1 S1.t1 211.043
R164 S1.n1 S1 9.69747
R165 S1.n1 S1 9.55258
R166 S1.n2 S1 8.1605
R167 S1 S1.n4 8.14595
R168 S1.n0 S1 6.8805
R169 S1.n3 S1 6.2405
R170 S1.n4 S1 5.04292
R171 S1 S1.n0 4.84898
R172 S1 S1.n3 4.6405
R173 S1.n4 S1 4.1605
R174 S1.n0 S1 4.0005
R175 S1 S1.n1 3.49141
R176 S1.n2 S1 2.7205
R177 B1.n10 B1.t4 384.529
R178 B1.n0 B1.t7 373.283
R179 B1.n4 B1.t5 351.861
R180 B1.n5 B1.t1 297.233
R181 B1.n6 B1.n4 214.362
R182 B1.n0 B1.t3 167.63
R183 B1.n11 B1.n10 158.768
R184 B1.n10 B1.t0 156.382
R185 B1.n7 B1.n6 152
R186 B1.n1 B1.n0 152
R187 B1.n4 B1.t6 109.215
R188 B1.n5 B1.t2 102.779
R189 B1.n6 B1.n5 47.4474
R190 B1.n8 B1.n7 11.7894
R191 B1.n2 B1.n1 10.3005
R192 B1.n1 B1 10.2005
R193 B1.n12 B1.n11 9.3005
R194 B1.n7 B1 5.86717
R195 B1.n11 B1 2.50165
R196 B1.n9 B1 2.313
R197 B1 B1.n3 1.79514
R198 B1.n12 B1 1.61055
R199 B1 B1.n9 1.40229
R200 B1.n3 B1 0.259429
R201 B1.n3 B1.n2 0.0793043
R202 B1.n2 B1 0.0793043
R203 B1.n9 B1.n8 0.0793043
R204 B1.n8 B1 0.0793043
R205 B1 B1.n12 0.0793043
R206 A1.n4 A1.t2 373.283
R207 A1.n0 A1.t3 347.577
R208 A1.n12 A1.t0 334.723
R209 A1.n8 A1.t1 323.476
R210 A1.n8 A1.t5 217.436
R211 A1.n12 A1.t4 206.19
R212 A1.n0 A1.t7 193.337
R213 A1.n4 A1.t6 167.63
R214 A1.n9 A1.n8 160.534
R215 A1.n13 A1.n12 159.315
R216 A1.n5 A1.n4 157.12
R217 A1.n1 A1.n0 156
R218 A1.n2 A1.n1 9.3005
R219 A1.n6 A1.n5 9.3005
R220 A1.n10 A1.n9 9.3005
R221 A1.n14 A1.n13 9.3005
R222 A1.n1 A1 4.8005
R223 A1.n13 A1 3.88621
R224 A1.n11 A1 3.563
R225 A1.n9 A1 3.29747
R226 A1.n5 A1 2.90183
R227 A1.n7 A1 1.90229
R228 A1 A1.n7 1.40229
R229 A1 A1.n3 1.38443
R230 A1.n14 A1 1.25118
R231 A1 A1.n11 0.973714
R232 A1.n3 A1 0.259429
R233 A1.n3 A1.n2 0.0793043
R234 A1.n2 A1 0.0793043
R235 A1.n7 A1.n6 0.0793043
R236 A1.n6 A1 0.0793043
R237 A1.n11 A1.n10 0.0793043
R238 A1.n10 A1 0.0793043
R239 A1 A1.n14 0.0793043
R240 S0.t0 S0 758.202
R241 S0.n0 S0.t0 755.481
R242 S0.n3 S0.t1 209.923
R243 S0 S0.n4 11.4429
R244 S0.n2 S0 10.0853
R245 S0.n2 S0 9.79492
R246 S0.n1 S0.n0 8.8005
R247 S0 S0.n3 6.5605
R248 S0.n3 S0 4.3205
R249 S0 S0.n2 3.10353
R250 S0.n4 S0 1.74595
R251 S0 S0.n1 1.55202
R252 S0.n4 S0 1.4405
R253 S0.n1 S0 1.2805
R254 S0.n0 S0 0.8005
R255 CIN.n3 CIN.t0 373.283
R256 CIN.n2 CIN.n0 357.442
R257 CIN.n1 CIN.t1 346.022
R258 CIN.n0 CIN.t5 325.082
R259 CIN.n0 CIN.t2 215.829
R260 CIN.n1 CIN.t4 193.337
R261 CIN.n3 CIN.t3 167.63
R262 CIN.n2 CIN.n1 152
R263 CIN.n4 CIN.n3 152
R264 CIN.n4 CIN.n2 88.4259
R265 CIN CIN.n4 5.3765
R266 B0.n9 B0.t3 384.529
R267 B0.n0 B0.t0 373.283
R268 B0.n4 B0.t2 351.861
R269 B0.n3 B0.t6 297.233
R270 B0.n5 B0.n4 214.362
R271 B0.n0 B0.t4 167.63
R272 B0.n10 B0.n9 157.921
R273 B0.n1 B0.n0 156.571
R274 B0.n9 B0.t7 156.382
R275 B0.n6 B0.n5 152
R276 B0.n4 B0.t1 109.215
R277 B0.n3 B0.t5 102.659
R278 B0.n5 B0.n3 47.4474
R279 B0.n7 B0.n6 10.2702
R280 B0.n6 B0 9.69747
R281 B0 B0.n1 9.37931
R282 B0.n11 B0.n10 9.3005
R283 B0.n10 B0 2.7205
R284 B0.n1 B0 2.59098
R285 B0.n2 B0 1.92014
R286 B0.n2 B0 1.79514
R287 B0.n8 B0 1.40229
R288 B0.n8 B0 0.259429
R289 B0.n7 B0.n2 0.0793043
R290 B0 B0.n7 0.0793043
R291 B0.n11 B0.n8 0.0793043
R292 B0 B0.n11 0.0793043
R293 A0.n3 A0.t5 373.283
R294 A0.n0 A0.t4 347.577
R295 A0.n11 A0.t7 334.723
R296 A0.n7 A0.t6 323.476
R297 A0.n7 A0.t2 217.436
R298 A0.n11 A0.t3 206.19
R299 A0.n0 A0.t0 193.337
R300 A0.n3 A0.t1 167.63
R301 A0.n12 A0.n11 152
R302 A0.n8 A0.n7 152
R303 A0.n4 A0.n3 152
R304 A0.n1 A0.n0 152
R305 A0.n9 A0.n8 17.8338
R306 A0.n1 A0 14.6672
R307 A0.n5 A0.n4 14.4205
R308 A0 A0.n1 13.3793
R309 A0.n13 A0.n12 10.4641
R310 A0.n8 A0 3.29747
R311 A0.n2 A0 3.15229
R312 A0.n4 A0 2.90183
R313 A0.n12 A0 2.13383
R314 A0.n6 A0 1.49157
R315 A0.n6 A0 1.40229
R316 A0.n2 A0 1.38443
R317 A0.n10 A0 0.973714
R318 A0.n10 A0 0.259429
R319 A0.n5 A0.n2 0.0793043
R320 A0 A0.n5 0.0793043
R321 A0.n9 A0.n6 0.0793043
R322 A0 A0.n9 0.0793043
R323 A0.n13 A0.n10 0.0793043
R324 A0 A0.n13 0.0793043
R325 VDD.n45 VDD.t28 731.032
R326 VDD.n74 VDD.t66 663.062
R327 VDD.n111 VDD.t60 663.062
R328 VDD.n114 VDD.t82 663.062
R329 VDD.n54 VDD.t48 663.062
R330 VDD.n37 VDD.n36 605.481
R331 VDD.n101 VDD.n20 605.481
R332 VDD.n127 VDD.n126 605.481
R333 VDD.n59 VDD.n58 605.481
R334 VDD.n39 VDD.n38 598.965
R335 VDD.n77 VDD.n75 598.965
R336 VDD.n143 VDD.n142 598.965
R337 VDD.n109 VDD.n15 598.965
R338 VDD.n119 VDD.n8 598.965
R339 VDD.n122 VDD.n121 598.965
R340 VDD.n116 VDD.n115 598.965
R341 VDD.n11 VDD.n10 598.965
R342 VDD.n29 VDD.n22 598.965
R343 VDD.n66 VDD.n65 598.965
R344 VDD.n86 VDD.n85 598.965
R345 VDD.n48 VDD.n43 598.965
R346 VDD.t67 VDD.t65 556.386
R347 VDD.t47 VDD.t45 556.386
R348 VDD.n33 VDD 538.664
R349 VDD.t21 VDD.t84 292.991
R350 VDD.t90 VDD.t23 292.991
R351 VDD.t28 VDD.t76 292.991
R352 VDD.t74 VDD.t25 292.991
R353 VDD.t20 VDD.t4 284.113
R354 VDD.t64 VDD.t90 284.113
R355 VDD.t76 VDD.t49 284.113
R356 VDD.t35 VDD.t27 284.113
R357 VDD.t84 VDD.t69 266.356
R358 VDD.t44 VDD.t74 266.356
R359 VDD.t86 VDD.t20 263.397
R360 VDD.t27 VDD.t70 263.397
R361 VDD.t69 VDD.t7 248.599
R362 VDD.t7 VDD.t88 248.599
R363 VDD.t88 VDD.t67 248.599
R364 VDD.t65 VDD.t5 248.599
R365 VDD.t5 VDD.t86 248.599
R366 VDD.t70 VDD.t33 248.599
R367 VDD.t33 VDD.t47 248.599
R368 VDD.t45 VDD.t72 248.599
R369 VDD.t72 VDD.t32 248.599
R370 VDD.t32 VDD.t44 248.599
R371 VDD.n25 VDD.n24 213.119
R372 VDD.n24 VDD.n23 213.119
R373 VDD.t4 VDD.t64 213.084
R374 VDD.t49 VDD.t35 213.084
R375 VDD.t25 VDD 189.409
R376 VDD.n24 VDD 157.856
R377 VDD.t38 VDD.t9 120.544
R378 VDD.t1 VDD.t56 120.544
R379 VDD.n36 VDD.t85 98.5005
R380 VDD.n142 VDD.t91 98.5005
R381 VDD.n20 VDD.t53 98.5005
R382 VDD.n121 VDD.t51 98.5005
R383 VDD.n126 VDD.t43 98.5005
R384 VDD.n22 VDD.t37 98.5005
R385 VDD.n58 VDD.t75 98.5005
R386 VDD.n43 VDD.t77 98.5005
R387 VDD.t15 VDD.t52 91.8434
R388 VDD.t42 VDD.t30 91.8434
R389 VDD.t17 VDD 91.8434
R390 VDD VDD.t21 88.7855
R391 VDD.t9 VDD.t59 83.2331
R392 VDD.t81 VDD.t1 83.2331
R393 VDD.t36 VDD.t63 78.928
R394 VDD.t11 VDD.t54 78.928
R395 VDD.t40 VDD.t0 78.928
R396 VDD.t78 VDD.t50 78.928
R397 VDD.t61 VDD.t38 66.0126
R398 VDD.t56 VDD.t79 66.0126
R399 VDD.n38 VDD.t89 63.3219
R400 VDD.n38 VDD.t68 63.3219
R401 VDD.n75 VDD.t6 63.3219
R402 VDD.n75 VDD.t87 63.3219
R403 VDD.n15 VDD.t55 63.3219
R404 VDD.n15 VDD.t62 63.3219
R405 VDD.n8 VDD.t2 63.3219
R406 VDD.n8 VDD.t57 63.3219
R407 VDD.n115 VDD.t80 63.3219
R408 VDD.n115 VDD.t41 63.3219
R409 VDD.n10 VDD.t39 63.3219
R410 VDD.n10 VDD.t10 63.3219
R411 VDD.n65 VDD.t46 63.3219
R412 VDD.n65 VDD.t73 63.3219
R413 VDD.n85 VDD.t71 63.3219
R414 VDD.n85 VDD.t34 63.3219
R415 VDD.t83 VDD.t3 61.7074
R416 VDD.t19 VDD.t61 61.7074
R417 VDD.t79 VDD.t12 61.7074
R418 VDD.t8 VDD.t58 61.7074
R419 VDD.t63 VDD.t83 58.8374
R420 VDD.t54 VDD.t19 58.8374
R421 VDD.t12 VDD.t40 58.8374
R422 VDD.t58 VDD.t78 58.8374
R423 VDD.t13 VDD.t15 50.2271
R424 VDD.t52 VDD.t36 50.2271
R425 VDD.t50 VDD.t42 50.2271
R426 VDD.t30 VDD.t17 50.2271
R427 VDD.n125 VDD.n122 43.9358
R428 VDD VDD.t13 43.0519
R429 VDD.t3 VDD.t11 41.6168
R430 VDD.t0 VDD.t8 41.6168
R431 VDD.t59 VDD.t81 37.3117
R432 VDD.n95 VDD.n94 34.6358
R433 VDD.n94 VDD.n93 34.6358
R434 VDD.n76 VDD.n1 34.6358
R435 VDD.n140 VDD.n1 34.6358
R436 VDD.n141 VDD.n140 34.6358
R437 VDD.n103 VDD.n102 34.6358
R438 VDD.n103 VDD.n14 34.6358
R439 VDD.n133 VDD.n120 34.6358
R440 VDD.n133 VDD.n132 34.6358
R441 VDD.n132 VDD.n131 34.6358
R442 VDD.n123 VDD.n5 34.6358
R443 VDD.n124 VDD.n123 34.6358
R444 VDD.n21 VDD.n17 34.6358
R445 VDD.n106 VDD.n17 34.6358
R446 VDD.n107 VDD.n106 34.6358
R447 VDD.n29 VDD.n28 34.6358
R448 VDD.n64 VDD.n56 34.6358
R449 VDD.n60 VDD.n56 34.6358
R450 VDD.n52 VDD.n49 34.6358
R451 VDD.n53 VDD.n52 34.6358
R452 VDD.n87 VDD.n53 34.6358
R453 VDD.n48 VDD.n44 34.6358
R454 VDD.n77 VDD.n76 31.624
R455 VDD.n120 VDD.n119 31.624
R456 VDD.n107 VDD.n11 31.624
R457 VDD.n87 VDD.n86 31.624
R458 VDD.n95 VDD.n37 28.9887
R459 VDD.n102 VDD.n101 28.9887
R460 VDD.n127 VDD.n124 28.9887
R461 VDD.n60 VDD.n59 28.9887
R462 VDD.n36 VDD.t22 27.9557
R463 VDD.n142 VDD.t24 27.9557
R464 VDD.n20 VDD.t14 27.9557
R465 VDD.n121 VDD.t31 27.9557
R466 VDD.n126 VDD.t18 27.9557
R467 VDD.n22 VDD.t16 27.9557
R468 VDD.n58 VDD.t26 27.9557
R469 VDD.n43 VDD.t29 27.9557
R470 VDD.n73 VDD.n39 27.1064
R471 VDD.n110 VDD.n109 27.1064
R472 VDD.n117 VDD.n116 27.1064
R473 VDD.n67 VDD.n66 27.1064
R474 VDD.n78 VDD.n74 25.6005
R475 VDD.n111 VDD.n7 25.6005
R476 VDD.n114 VDD.n113 25.6005
R477 VDD.n84 VDD.n54 25.6005
R478 VDD.n35 VDD.n33 23.7181
R479 VDD.n25 VDD.n19 23.7181
R480 VDD.n28 VDD.n23 23.7181
R481 VDD.n45 VDD.n44 23.7181
R482 VDD.n37 VDD.n35 21.4593
R483 VDD.n101 VDD.n19 21.4593
R484 VDD.n74 VDD.n73 18.824
R485 VDD.n111 VDD.n110 18.824
R486 VDD.n117 VDD.n114 18.824
R487 VDD.n67 VDD.n54 18.824
R488 VDD.n93 VDD.n39 17.3181
R489 VDD.n109 VDD.n14 17.3181
R490 VDD.n116 VDD.n5 17.3181
R491 VDD.n66 VDD.n64 17.3181
R492 VDD.n78 VDD.n77 12.8005
R493 VDD.n119 VDD.n7 12.8005
R494 VDD.n113 VDD.n11 12.8005
R495 VDD.n86 VDD.n84 12.8005
R496 VDD.n143 VDD.n141 9.78874
R497 VDD.n131 VDD.n122 9.78874
R498 VDD.n29 VDD.n21 9.78874
R499 VDD.n49 VDD.n48 9.78874
R500 VDD VDD.n45 9.3031
R501 VDD VDD.n33 9.3031
R502 VDD.n46 VDD.n44 9.3005
R503 VDD.n48 VDD.n47 9.3005
R504 VDD.n50 VDD.n49 9.3005
R505 VDD.n52 VDD.n51 9.3005
R506 VDD.n53 VDD.n41 9.3005
R507 VDD.n88 VDD.n87 9.3005
R508 VDD.n86 VDD.n42 9.3005
R509 VDD.n84 VDD.n83 9.3005
R510 VDD.n69 VDD.n54 9.3005
R511 VDD.n68 VDD.n67 9.3005
R512 VDD.n66 VDD.n55 9.3005
R513 VDD.n64 VDD.n63 9.3005
R514 VDD.n62 VDD.n56 9.3005
R515 VDD.n61 VDD.n60 9.3005
R516 VDD.n26 VDD.n23 9.3005
R517 VDD.n28 VDD.n27 9.3005
R518 VDD.n100 VDD.n29 9.3005
R519 VDD.n21 VDD.n18 9.3005
R520 VDD.n104 VDD.n17 9.3005
R521 VDD.n106 VDD.n105 9.3005
R522 VDD.n108 VDD.n107 9.3005
R523 VDD.n12 VDD.n11 9.3005
R524 VDD.n113 VDD.n112 9.3005
R525 VDD.n114 VDD.n9 9.3005
R526 VDD.n118 VDD.n117 9.3005
R527 VDD.n116 VDD.n4 9.3005
R528 VDD.n134 VDD.n5 9.3005
R529 VDD.n123 VDD.n6 9.3005
R530 VDD.n130 VDD.n124 9.3005
R531 VDD.n129 VDD.n122 9.3005
R532 VDD.n131 VDD.n130 9.3005
R533 VDD.n132 VDD.n6 9.3005
R534 VDD.n134 VDD.n133 9.3005
R535 VDD.n120 VDD.n4 9.3005
R536 VDD.n119 VDD.n118 9.3005
R537 VDD.n9 VDD.n7 9.3005
R538 VDD.n112 VDD.n111 9.3005
R539 VDD.n110 VDD.n12 9.3005
R540 VDD.n109 VDD.n108 9.3005
R541 VDD.n105 VDD.n14 9.3005
R542 VDD.n104 VDD.n103 9.3005
R543 VDD.n102 VDD.n18 9.3005
R544 VDD.n101 VDD.n100 9.3005
R545 VDD.n27 VDD.n19 9.3005
R546 VDD.n26 VDD.n25 9.3005
R547 VDD.n141 VDD.n0 9.3005
R548 VDD.n140 VDD.n139 9.3005
R549 VDD.n138 VDD.n1 9.3005
R550 VDD.n76 VDD.n2 9.3005
R551 VDD.n77 VDD.n71 9.3005
R552 VDD.n79 VDD.n78 9.3005
R553 VDD.n74 VDD.n70 9.3005
R554 VDD.n73 VDD.n72 9.3005
R555 VDD.n40 VDD.n39 9.3005
R556 VDD.n93 VDD.n92 9.3005
R557 VDD.n94 VDD.n32 9.3005
R558 VDD.n96 VDD.n95 9.3005
R559 VDD.n37 VDD.n31 9.3005
R560 VDD.n35 VDD.n34 9.3005
R561 VDD.n90 VDD.n89 8.76203
R562 VDD.n82 VDD.n81 8.76203
R563 VDD.n136 VDD.n3 8.76203
R564 VDD.n98 VDD.n30 8.76203
R565 VDD.n91 VDD.n90 8.76203
R566 VDD.n81 VDD.n80 8.76203
R567 VDD.n137 VDD.n136 8.76203
R568 VDD.n98 VDD.n97 8.76065
R569 VDD.n136 VDD.n135 7.9105
R570 VDD.n81 VDD.n13 7.9105
R571 VDD.n90 VDD.n16 7.9105
R572 VDD.n99 VDD.n98 7.9105
R573 VDD.n144 VDD.n143 7.65909
R574 VDD.n128 VDD.n127 7.13126
R575 VDD.n59 VDD.n57 7.12063
R576 VDD VDD.n144 0.159538
R577 VDD.n61 VDD.n57 0.148519
R578 VDD.n144 VDD.n0 0.141672
R579 VDD.n47 VDD.n46 0.120292
R580 VDD.n51 VDD.n50 0.120292
R581 VDD.n51 VDD.n41 0.120292
R582 VDD.n88 VDD.n42 0.120292
R583 VDD.n83 VDD.n42 0.120292
R584 VDD.n69 VDD.n68 0.120292
R585 VDD.n68 VDD.n55 0.120292
R586 VDD.n63 VDD.n62 0.120292
R587 VDD.n62 VDD.n61 0.120292
R588 VDD.n96 VDD.n32 0.120292
R589 VDD.n92 VDD.n32 0.120292
R590 VDD.n72 VDD.n40 0.120292
R591 VDD.n72 VDD.n70 0.120292
R592 VDD.n79 VDD.n71 0.120292
R593 VDD.n71 VDD.n2 0.120292
R594 VDD.n139 VDD.n138 0.120292
R595 VDD.n139 VDD.n0 0.120292
R596 VDD.n57 VDD 0.11354
R597 VDD.n47 VDD.n30 0.0968542
R598 VDD VDD.n31 0.0968542
R599 VDD.n97 VDD.n31 0.0968542
R600 VDD.n89 VDD.n41 0.0916458
R601 VDD.n92 VDD.n91 0.0916458
R602 VDD.n83 VDD.n82 0.0864375
R603 VDD.n80 VDD.n70 0.0864375
R604 VDD.n34 VDD 0.0825312
R605 VDD.n55 VDD.n3 0.0812292
R606 VDD.n137 VDD.n2 0.0812292
R607 VDD.n46 VDD 0.0603958
R608 VDD.n104 VDD.n18 0.0603958
R609 VDD.n105 VDD.n104 0.0603958
R610 VDD.n108 VDD.n12 0.0603958
R611 VDD.n112 VDD.n12 0.0603958
R612 VDD.n118 VDD.n9 0.0603958
R613 VDD.n118 VDD.n4 0.0603958
R614 VDD.n134 VDD.n6 0.0603958
R615 VDD.n130 VDD.n6 0.0603958
R616 VDD.n130 VDD.n129 0.0603958
R617 VDD.n100 VDD 0.0486771
R618 VDD.n100 VDD.n99 0.0486771
R619 VDD.n128 VDD.n125 0.0469218
R620 VDD.n105 VDD.n16 0.0460729
R621 VDD.n112 VDD.n13 0.0434688
R622 VDD.n135 VDD.n4 0.0408646
R623 VDD.n63 VDD.n3 0.0395625
R624 VDD.n138 VDD.n137 0.0395625
R625 VDD.n82 VDD.n69 0.0343542
R626 VDD.n80 VDD.n79 0.0343542
R627 VDD.n27 VDD 0.0304479
R628 VDD.n89 VDD.n88 0.0291458
R629 VDD.n91 VDD.n40 0.0291458
R630 VDD.n50 VDD.n30 0.0239375
R631 VDD.n34 VDD 0.0239375
R632 VDD.n97 VDD.n96 0.0239375
R633 VDD.n135 VDD.n134 0.0200312
R634 VDD.n13 VDD.n9 0.0174271
R635 VDD.n129 VDD.n128 0.0148846
R636 VDD.n108 VDD.n16 0.0148229
R637 VDD.n27 VDD 0.0122188
R638 VDD.n99 VDD.n18 0.0122188
R639 VDD.n125 VDD 0.0109167
R640 VDD VDD.n26 0.00180208
R641 GND.n56 GND.n55 1198.25
R642 GND.n54 GND.n53 1198.25
R643 GND.n54 GND.n30 1198.25
R644 GND.n55 GND.n29 1198.25
R645 GND GND.n54 783.173
R646 GND.n55 GND 783.173
R647 GND.t33 GND.t72 598.058
R648 GND.t54 GND.t1 598.058
R649 GND.t42 GND.t9 598.058
R650 GND.t5 GND.t84 598.058
R651 GND.t50 GND.t28 455.663
R652 GND.t30 GND.t74 455.663
R653 GND GND.t25 455.663
R654 GND.t15 GND.t90 455.663
R655 GND.t36 GND.t23 455.663
R656 GND.t17 GND 455.663
R657 GND.t59 GND.t33 412.945
R658 GND.t1 GND.t47 412.945
R659 GND.t9 GND.t65 412.945
R660 GND.t81 GND.t5 412.945
R661 GND.t63 GND.t76 391.587
R662 GND.t52 GND.t35 391.587
R663 GND.t0 GND.t70 391.587
R664 GND.t56 GND.t44 391.587
R665 GND.t38 GND.t69 391.587
R666 GND.t11 GND.t86 391.587
R667 GND.t40 GND.t4 391.587
R668 GND.t78 GND.t88 391.587
R669 GND.t72 GND.t61 327.509
R670 GND.t45 GND.t54 327.509
R671 GND.t67 GND.t42 327.509
R672 GND.t84 GND.t79 327.509
R673 GND.t3 GND.t49 306.149
R674 GND.t61 GND.t27 306.149
R675 GND.t12 GND.t45 306.149
R676 GND.t58 GND.t32 306.149
R677 GND.t83 GND.t7 306.149
R678 GND.t19 GND.t67 306.149
R679 GND.t79 GND.t20 306.149
R680 GND.t8 GND.t64 306.149
R681 GND.t49 GND.t63 291.909
R682 GND.t27 GND.t52 291.909
R683 GND.t70 GND.t12 291.909
R684 GND.t44 GND.t58 291.909
R685 GND.t69 GND.t83 291.909
R686 GND.t86 GND.t19 291.909
R687 GND.t20 GND.t40 291.909
R688 GND.t64 GND.t78 291.909
R689 GND.t28 GND.t13 249.191
R690 GND.t76 GND.t50 249.191
R691 GND.t74 GND.t56 249.191
R692 GND.t25 GND.t30 249.191
R693 GND.t21 GND.t15 249.191
R694 GND.t90 GND.t38 249.191
R695 GND.t88 GND.t36 249.191
R696 GND.t23 GND.t17 249.191
R697 GND.n110 GND.t48 239.281
R698 GND.n11 GND.t60 239.281
R699 GND.n102 GND.t82 239.281
R700 GND.n18 GND.t66 239.281
R701 GND.t13 GND 213.593
R702 GND GND.t21 213.593
R703 GND.t35 GND.t3 206.472
R704 GND.t32 GND.t0 206.472
R705 GND.t7 GND.t11 206.472
R706 GND.t4 GND.t8 206.472
R707 GND.n126 GND.n2 199.739
R708 GND.n34 GND.n33 199.739
R709 GND.n84 GND.n83 199.739
R710 GND.n60 GND.n28 199.739
R711 GND.n48 GND.n36 198.964
R712 GND.n108 GND.n14 198.964
R713 GND.n116 GND.n7 198.964
R714 GND.n122 GND.n121 198.964
R715 GND.n113 GND.n10 198.964
R716 GND.n41 GND.n40 198.964
R717 GND.n64 GND.n63 198.964
R718 GND.n74 GND.n73 198.964
R719 GND.n76 GND.n75 198.964
R720 GND.n90 GND.n89 198.964
R721 GND.n79 GND.n77 198.964
R722 GND.n70 GND.n23 198.964
R723 GND.t47 GND.t59 185.113
R724 GND.t65 GND.t81 185.113
R725 GND.n2 GND.t75 60.0005
R726 GND.n33 GND.t51 60.0005
R727 GND.n83 GND.t37 60.0005
R728 GND.n28 GND.t91 60.0005
R729 GND.n36 GND.t29 46.8576
R730 GND.n121 GND.t31 46.8576
R731 GND.n63 GND.t16 46.8576
R732 GND.n89 GND.t24 46.8576
R733 GND.n36 GND.t77 38.5719
R734 GND.n14 GND.t73 38.5719
R735 GND.n14 GND.t34 38.5719
R736 GND.n7 GND.t46 38.5719
R737 GND.n7 GND.t71 38.5719
R738 GND.n121 GND.t57 38.5719
R739 GND.n10 GND.t2 38.5719
R740 GND.n10 GND.t55 38.5719
R741 GND.n40 GND.t53 38.5719
R742 GND.n40 GND.t62 38.5719
R743 GND.n63 GND.t39 38.5719
R744 GND.n73 GND.t43 38.5719
R745 GND.n73 GND.t10 38.5719
R746 GND.n75 GND.t80 38.5719
R747 GND.n75 GND.t41 38.5719
R748 GND.n89 GND.t89 38.5719
R749 GND.n77 GND.t6 38.5719
R750 GND.n77 GND.t85 38.5719
R751 GND.n23 GND.t87 38.5719
R752 GND.n23 GND.t68 38.5719
R753 GND.n49 GND.n31 34.6358
R754 GND.n47 GND.n46 34.6358
R755 GND.n46 GND.n37 34.6358
R756 GND.n37 GND.n13 34.6358
R757 GND.n118 GND.n117 34.6358
R758 GND.n118 GND.n1 34.6358
R759 GND.n114 GND.n4 34.6358
R760 GND.n120 GND.n4 34.6358
R761 GND.n123 GND.n120 34.6358
R762 GND.n39 GND.n38 34.6358
R763 GND.n42 GND.n39 34.6358
R764 GND.n62 GND.n27 34.6358
R765 GND.n66 GND.n65 34.6358
R766 GND.n66 GND.n20 34.6358
R767 GND.n72 GND.n20 34.6358
R768 GND.n96 GND.n95 34.6358
R769 GND.n95 GND.n94 34.6358
R770 GND.n81 GND.n80 34.6358
R771 GND.n86 GND.n81 34.6358
R772 GND.n87 GND.n86 34.6358
R773 GND.n68 GND.n24 34.6358
R774 GND.n69 GND.n68 34.6358
R775 GND.n108 GND.n13 31.624
R776 GND.n114 GND.n113 31.624
R777 GND.n74 GND.n72 31.624
R778 GND.n80 GND.n79 31.624
R779 GND.n127 GND.n126 30.7593
R780 GND.n88 GND.n84 30.7593
R781 GND.n116 GND.n6 27.1064
R782 GND.n41 GND.n16 27.1064
R783 GND.n101 GND.n76 27.1064
R784 GND.n70 GND.n22 27.1064
R785 GND.n110 GND.n109 25.6005
R786 GND.n112 GND.n11 25.6005
R787 GND.n103 GND.n102 25.6005
R788 GND.n78 GND.n18 25.6005
R789 GND.n2 GND.t26 25.4291
R790 GND.n33 GND.t14 25.4291
R791 GND.n83 GND.t18 25.4291
R792 GND.n28 GND.t22 25.4291
R793 GND.n53 GND.n31 23.7181
R794 GND.n32 GND.n30 23.7181
R795 GND.n56 GND.n27 23.7181
R796 GND.n59 GND.n29 23.7181
R797 GND.n126 GND.n1 22.9652
R798 GND.n38 GND.n34 22.9652
R799 GND.n94 GND.n84 22.9652
R800 GND.n60 GND.n24 22.9652
R801 GND.n34 GND.n32 21.4593
R802 GND.n60 GND.n59 21.4593
R803 GND.n110 GND.n6 18.824
R804 GND.n16 GND.n11 18.824
R805 GND.n102 GND.n101 18.824
R806 GND.n22 GND.n18 18.824
R807 GND.n117 GND.n116 17.3181
R808 GND.n42 GND.n41 17.3181
R809 GND.n96 GND.n76 17.3181
R810 GND.n70 GND.n69 17.3181
R811 GND.n85 GND.n3 16.7052
R812 GND.n99 GND.n8 16.7052
R813 GND.n106 GND.n105 16.7052
R814 GND.n44 GND.n26 16.7052
R815 GND.n122 GND.n0 13.3148
R816 GND.n91 GND.n90 13.3148
R817 GND.n109 GND.n108 12.8005
R818 GND.n113 GND.n112 12.8005
R819 GND.n103 GND.n74 12.8005
R820 GND.n79 GND.n78 12.8005
R821 GND.n57 GND.n29 9.3005
R822 GND.n59 GND.n58 9.3005
R823 GND.n61 GND.n60 9.3005
R824 GND.n25 GND.n24 9.3005
R825 GND.n68 GND.n67 9.3005
R826 GND.n69 GND.n21 9.3005
R827 GND.n71 GND.n70 9.3005
R828 GND.n22 GND.n17 9.3005
R829 GND.n104 GND.n18 9.3005
R830 GND.n78 GND.n19 9.3005
R831 GND.n100 GND.n79 9.3005
R832 GND.n98 GND.n80 9.3005
R833 GND.n97 GND.n81 9.3005
R834 GND.n86 GND.n82 9.3005
R835 GND.n93 GND.n87 9.3005
R836 GND.n92 GND.n84 9.3005
R837 GND.n94 GND.n93 9.3005
R838 GND.n95 GND.n82 9.3005
R839 GND.n97 GND.n96 9.3005
R840 GND.n98 GND.n76 9.3005
R841 GND.n101 GND.n100 9.3005
R842 GND.n102 GND.n19 9.3005
R843 GND.n104 GND.n103 9.3005
R844 GND.n74 GND.n17 9.3005
R845 GND.n72 GND.n71 9.3005
R846 GND.n21 GND.n20 9.3005
R847 GND.n67 GND.n66 9.3005
R848 GND.n65 GND.n25 9.3005
R849 GND.n62 GND.n61 9.3005
R850 GND.n58 GND.n27 9.3005
R851 GND.n57 GND.n56 9.3005
R852 GND.n52 GND.n30 9.3005
R853 GND.n51 GND.n32 9.3005
R854 GND.n50 GND.n34 9.3005
R855 GND.n38 GND.n35 9.3005
R856 GND.n45 GND.n39 9.3005
R857 GND.n43 GND.n42 9.3005
R858 GND.n41 GND.n15 9.3005
R859 GND.n107 GND.n16 9.3005
R860 GND.n12 GND.n11 9.3005
R861 GND.n112 GND.n111 9.3005
R862 GND.n113 GND.n9 9.3005
R863 GND.n115 GND.n114 9.3005
R864 GND.n5 GND.n4 9.3005
R865 GND.n120 GND.n119 9.3005
R866 GND.n124 GND.n123 9.3005
R867 GND.n126 GND.n125 9.3005
R868 GND.n124 GND.n1 9.3005
R869 GND.n119 GND.n118 9.3005
R870 GND.n117 GND.n5 9.3005
R871 GND.n116 GND.n115 9.3005
R872 GND.n9 GND.n6 9.3005
R873 GND.n111 GND.n110 9.3005
R874 GND.n109 GND.n12 9.3005
R875 GND.n108 GND.n107 9.3005
R876 GND.n15 GND.n13 9.3005
R877 GND.n43 GND.n37 9.3005
R878 GND.n46 GND.n45 9.3005
R879 GND.n47 GND.n35 9.3005
R880 GND.n50 GND.n49 9.3005
R881 GND.n51 GND.n31 9.3005
R882 GND.n53 GND.n52 9.3005
R883 GND.n49 GND.n48 5.64756
R884 GND.n64 GND.n62 5.64756
R885 GND.n48 GND.n47 4.14168
R886 GND.n123 GND.n122 4.14168
R887 GND.n65 GND.n64 4.14168
R888 GND.n90 GND.n87 4.14168
R889 GND.n61 GND.n25 0.0603958
R890 GND.n67 GND.n25 0.0603958
R891 GND.n71 GND.n21 0.0603958
R892 GND.n71 GND.n17 0.0603958
R893 GND.n104 GND.n19 0.0603958
R894 GND.n100 GND.n19 0.0603958
R895 GND.n98 GND.n97 0.0603958
R896 GND.n97 GND.n82 0.0603958
R897 GND.n93 GND.n92 0.0603958
R898 GND.n50 GND.n35 0.0603958
R899 GND.n45 GND.n35 0.0603958
R900 GND.n43 GND.n15 0.0603958
R901 GND.n107 GND.n15 0.0603958
R902 GND.n111 GND.n12 0.0603958
R903 GND.n111 GND.n9 0.0603958
R904 GND.n115 GND.n5 0.0603958
R905 GND.n119 GND.n5 0.0603958
R906 GND.n125 GND.n124 0.0603958
R907 GND.n93 GND.n85 0.0512812
R908 GND.n124 GND.n3 0.0512812
R909 GND.n91 GND.n88 0.0503767
R910 GND.n127 GND.n0 0.0503767
R911 GND.n61 GND 0.0486771
R912 GND.n99 GND.n98 0.0486771
R913 GND GND.n50 0.0486771
R914 GND.n115 GND.n8 0.0486771
R915 GND.n105 GND.n104 0.0460729
R916 GND.n106 GND.n12 0.0460729
R917 GND.n26 GND.n21 0.0434688
R918 GND.n44 GND.n43 0.0434688
R919 GND.n58 GND 0.0304479
R920 GND GND.n51 0.0304479
R921 GND.n67 GND.n26 0.0174271
R922 GND.n45 GND.n44 0.0174271
R923 GND.n105 GND.n17 0.0148229
R924 GND.n107 GND.n106 0.0148229
R925 GND.n58 GND 0.0122188
R926 GND.n100 GND.n99 0.0122188
R927 GND.n51 GND 0.0122188
R928 GND.n9 GND.n8 0.0122188
R929 GND.n92 GND.n91 0.0114518
R930 GND.n125 GND.n0 0.0114518
R931 GND.n88 GND 0.0109167
R932 GND GND.n127 0.0109167
R933 GND.n85 GND.n82 0.00961458
R934 GND.n119 GND.n3 0.00961458
R935 GND GND.n57 0.00180208
R936 GND.n52 GND 0.00180208
C0 CIN B0 0.78726f
C1 a_114_n1033# A2 0.75375f
C2 A1 B1 0.99653f
C3 A1 a_491_n289# 0.75426f
C4 a_420_461# VDD 0.17323f
C5 B3 A3 0.99653f
C6 a_1033_95# A0 0.16271f
C7 VDD a_491_n1569# 0.35364f
C8 VDD A2 0.4102f
C9 a_776_461# VDD 0.16905f
C10 CIN A0 0.49561f
C11 x4.CIN A3 0.49192f
C12 a_114_n1033# VDD 0.34271f
C13 a_908_n545# VDD 0.17383f
C14 B1 x2.CIN 0.68366f
C15 x2.CIN a_491_n289# 0.25128f
C16 a_114_247# VDD 0.32877f
C17 a_152_n1851# A3 0.16271f
C18 x3.CIN a_491_n289# 0.16797f
C19 B3 a_491_n1569# 0.17147f
C20 a_545_n1825# VDD 0.17162f
C21 S0 VDD 0.22586f
C22 x4.CIN a_491_n1569# 0.25192f
C23 a_152_n571# VDD 0.28574f
C24 a_114_247# B0 0.17223f
C25 S3 VDD 0.11663f
C26 VDD B0 0.69312f
C27 VDD a_420_n819# 0.17416f
C28 B3 VDD 0.73275f
C29 x4.CIN a_114_n1033# 0.18897f
C30 B2 A2 0.9494f
C31 COUT a_491_n1569# 0.14389f
C32 A2 a_1033_n1185# 0.16271f
C33 A1 VDD 0.40854f
C34 S1 VDD 0.11341f
C35 B1 a_491_n289# 0.17151f
C36 x3.CIN A2 0.46223f
C37 a_114_247# A0 0.75411f
C38 x4.CIN VDD 0.56594f
C39 a_545_n545# VDD 0.1712f
C40 a_114_n1033# B2 0.17144f
C41 VDD A0 0.38615f
C42 a_114_247# x2.CIN 0.18403f
C43 a_152_n1851# VDD 0.28021f
C44 A1 a_152_n571# 0.16271f
C45 a_114_n1033# x3.CIN 0.22289f
C46 a_152_n571# S1 0.15243f
C47 VDD B2 0.72964f
C48 VDD x2.CIN 0.57345f
C49 a_908_n1825# VDD 0.17406f
C50 VDD a_1033_n1185# 0.30638f
C51 VDD COUT 0.26892f
C52 S2 VDD 0.22762f
C53 x3.CIN VDD 0.96948f
C54 A0 B0 0.95348f
C55 B3 x4.CIN 0.6862f
C56 S3 a_152_n1851# 0.15117f
C57 CIN a_420_461# 0.10214f
C58 a_491_n1569# A3 0.75426f
C59 A1 x2.CIN 0.49204f
C60 a_1033_95# VDD 0.3001f
C61 VDD a_776_n819# 0.16963f
C62 CIN a_114_247# 0.25565f
C63 B1 VDD 0.76343f
C64 VDD a_491_n289# 0.35848f
C65 CIN VDD 0.64448f
C66 S0 a_1033_95# 0.15257f
C67 VDD A3 0.38992f
C68 x3.CIN B2 0.66869f
C69 S2 a_1033_n1185# 0.15275f
C70 COUT GND 0.46205f
C71 S3 GND 0.35385f
C72 B3 GND 0.79772f
C73 A3 GND 0.7035f
C74 S2 GND 0.42867f
C75 B2 GND 0.90269f
C76 A2 GND 0.85954f
C77 S1 GND 0.34912f
C78 B1 GND 0.7728f
C79 A1 GND 0.67628f
C80 S0 GND 0.42386f
C81 CIN GND 1.64943f
C82 B0 GND 0.96296f
C83 A0 GND 0.89537f
C84 VDD GND 18.63293f
C85 a_908_n1459# GND 0.16535f
C86 a_545_n1459# GND 0.17207f
C87 a_491_n1569# GND 0.66239f
C88 a_152_n1851# GND 0.32632f
C89 a_776_n1185# GND 0.17222f
C90 a_420_n1185# GND 0.16675f
C91 x4.CIN GND 1.03632f
C92 a_1033_n1185# GND 0.31175f
C93 a_114_n1033# GND 0.65791f
C94 x3.CIN GND 0.64047f
C95 a_908_n179# GND 0.16542f
C96 a_545_n179# GND 0.17221f
C97 a_491_n289# GND 0.64981f
C98 a_152_n571# GND 0.32106f
C99 a_776_95# GND 0.17214f
C100 a_420_95# GND 0.16641f
C101 x2.CIN GND 0.99607f
C102 a_1033_95# GND 0.31884f
C103 a_114_247# GND 0.66588f
C104 VDD.t56 GND 0.13035f
C105 VDD.t1 GND 0.14238f
C106 VDD.t9 GND 0.14238f
C107 VDD.t38 GND 0.13035f
C108 VDD.n24 GND 0.30831f
C109 VDD.t23 GND 0.21053f
C110 VDD.t65 GND 0.13225f
C111 VDD.t67 GND 0.13225f
C112 VDD.n33 GND 0.14228f
C113 VDD.t45 GND 0.13225f
C114 VDD.t47 GND 0.13225f
C115 VDD.t28 GND 0.18614f
C116 VDD.n45 GND 0.18028f
C117 VDD.n81 GND 0.52722f
C118 VDD.n90 GND 0.52722f
C119 VDD.n98 GND 0.52722f
C120 VDD.n136 GND 0.52722f
C121 A0.n0 GND 0.19142f
C122 A0.n2 GND 0.38688f
C123 A0.t5 GND 0.10428f
C124 A0.n3 GND 0.19114f
C125 A0.n6 GND 0.25302f
C126 A0.n7 GND 0.19159f
C127 A0.n10 GND 0.11772f
C128 A0.n11 GND 0.19152f
C129 B0.n0 GND 0.18351f
C130 B0.n1 GND 0.11353f
C131 B0.n2 GND 0.30393f
C132 B0.n3 GND 0.171f
C133 B0.t2 GND 0.10113f
C134 B0.n4 GND 0.18028f
C135 B0.n5 GND 0.13862f
C136 B0.n8 GND 0.14499f
C137 B0.t3 GND 0.10161f
C138 B0.n9 GND 0.18523f
C139 B0.n10 GND 0.15118f
C140 CIN.n0 GND 0.31416f
C141 CIN.n1 GND 0.14897f
C142 CIN.n2 GND 0.54753f
C143 CIN.n3 GND 0.14865f
C144 CIN.n4 GND 0.11615f
C145 A1.n0 GND 0.19204f
C146 A1.n3 GND 0.1501f
C147 A1.t2 GND 0.10353f
C148 A1.n4 GND 0.19179f
C149 A1.n5 GND 0.10534f
C150 A1.n7 GND 0.28444f
C151 A1.n8 GND 0.19375f
C152 A1.n9 GND 0.11479f
C153 A1.n11 GND 0.38411f
C154 A1.n12 GND 0.19194f
C155 A1.n14 GND 0.16655f
C156 B1.n0 GND 0.18159f
C157 B1.n3 GND 0.17541f
C158 B1.t5 GND 0.10114f
C159 B1.n4 GND 0.18029f
C160 B1.n5 GND 0.17096f
C161 B1.n6 GND 0.13863f
C162 B1.n9 GND 0.30395f
C163 B1.t4 GND 0.10162f
C164 B1.n10 GND 0.18509f
C165 B1.n11 GND 0.14986f
C166 B1.n12 GND 0.19581f
C167 A2.n0 GND 0.19187f
C168 A2.n2 GND 0.38779f
C169 A2.t5 GND 0.10452f
C170 A2.n3 GND 0.19159f
C171 A2.n6 GND 0.25362f
C172 A2.n7 GND 0.19204f
C173 A2.n10 GND 0.118f
C174 A2.n11 GND 0.19197f
C175 B2.n0 GND 0.17996f
C176 B2.n1 GND 0.11134f
C177 B2.n2 GND 0.29806f
C178 B2.n3 GND 0.16769f
C179 B2.n4 GND 0.1768f
C180 B2.n5 GND 0.13594f
C181 B2.n8 GND 0.14219f
C182 B2.n9 GND 0.18165f
C183 B2.n10 GND 0.14826f
C184 A3.n0 GND 0.1893f
C185 A3.n3 GND 0.14796f
C186 A3.t2 GND 0.10205f
C187 A3.n4 GND 0.18905f
C188 A3.n5 GND 0.10384f
C189 A3.n7 GND 0.28038f
C190 A3.n8 GND 0.19099f
C191 A3.n9 GND 0.11315f
C192 A3.n11 GND 0.37863f
C193 A3.n12 GND 0.1892f
C194 A3.n14 GND 0.16417f
C195 B3.n0 GND 0.17856f
C196 B3.n3 GND 0.17249f
C197 B3.n4 GND 0.17729f
C198 B3.n5 GND 0.16811f
C199 B3.n6 GND 0.13632f
C200 B3.n9 GND 0.29889f
C201 B3.n10 GND 0.18201f
C202 B3.n11 GND 0.14736f
C203 B3.n12 GND 0.19254f
.ends
