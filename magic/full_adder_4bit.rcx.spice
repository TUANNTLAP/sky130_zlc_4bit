* NGSPICE file created from full_adder_4bit.ext - technology: sky130A

.subckt full_adder_4bit A0 A2 B0 B2 S0 S2 CIN S1 B1 A1 S3 COUT A3 B3 VGND VPWR
X0 VPWR.t6 a_114_247# x2.CIN x1.VPB sky130_fd_pr__pfet_01v8_hvt ad=0.14785 pd=1.345 as=0.26 ps=2.52 w=1 l=0.15
X1 a_246_95# A0.t3 VGND.t3 x4.VNB sky130_fd_pr__nfet_01v8 ad=0.063 pd=0.72 as=0.10235 ps=0.995 w=0.42 l=0.15
X2 VPWR.t28 A2.t4 a_1201_n819# x3.VPB sky130_fd_pr__pfet_01v8_hvt ad=0.14785 pd=1.345 as=0.0693 ps=0.75 w=0.42 l=0.15
X3 VGND.t35 B1.t5 a_908_n179# x4.VNB sky130_fd_pr__nfet_01v8 ad=0.0567 pd=0.69 as=0.1092 ps=1.36 w=0.42 l=0.15
X4 VGND.t0 CIN.t1 a_776_95# x4.VNB sky130_fd_pr__nfet_01v8 ad=0.0567 pd=0.69 as=0.0567 ps=0.69 w=0.42 l=0.15
X5 S0.t1 a_1033_95# VPWR.t14 x1.VPB sky130_fd_pr__pfet_01v8_hvt ad=0.26 pd=2.52 as=0.14785 ps=1.345 w=1 l=0.15
X6 a_1033_n1185# a_114_n1033# a_776_n1185# x4.VNB sky130_fd_pr__nfet_01v8 ad=0.0693 pd=0.75 as=0.06195 ps=0.715 w=0.42 l=0.15
X7 a_776_n819# A2.t5 VPWR.t29 x3.VPB sky130_fd_pr__pfet_01v8_hvt ad=0.06195 pd=0.715 as=0.0567 ps=0.69 w=0.42 l=0.15
X8 a_377_n1459# B3.t7 a_281_n1459# x4.VNB sky130_fd_pr__nfet_01v8 ad=0.0441 pd=0.63 as=0.0693 ps=0.75 w=0.42 l=0.15
X9 a_1129_n1185# x3.CIN a_1033_n1185# x4.VNB sky130_fd_pr__nfet_01v8 ad=0.0441 pd=0.63 as=0.0693 ps=0.75 w=0.42 l=0.15
X10 a_152_n1851# VGND.t43 a_377_n1459# x4.VNB sky130_fd_pr__nfet_01v8 ad=0.0693 pd=0.75 as=0.0441 ps=0.63 w=0.42 l=0.15
X11 a_1129_n819# x3.CIN a_1033_n1185# x3.VPB sky130_fd_pr__pfet_01v8_hvt ad=0.0441 pd=0.63 as=0.0693 ps=0.75 w=0.42 l=0.15
X12 VGND.t38 B3.t5 a_908_n1459# x4.VNB sky130_fd_pr__nfet_01v8 ad=0.0567 pd=0.69 as=0.1092 ps=1.36 w=0.42 l=0.15
X13 a_545_n179# x2.CIN VGND.t15 x4.VNB sky130_fd_pr__nfet_01v8 ad=0.0567 pd=0.69 as=0.0567 ps=0.69 w=0.42 l=0.15
X14 a_908_n1459# A3.t5 VGND.t27 x4.VNB sky130_fd_pr__nfet_01v8 ad=0.0567 pd=0.69 as=0.0567 ps=0.69 w=0.42 l=0.15
X15 a_776_n819# B2.t5 VPWR.t26 x3.VPB sky130_fd_pr__pfet_01v8_hvt ad=0.0567 pd=0.69 as=0.1092 ps=1.36 w=0.42 l=0.15
X16 a_420_n819# x3.CIN a_114_n1033# x3.VPB sky130_fd_pr__pfet_01v8_hvt ad=0.0567 pd=0.69 as=0.0567 ps=0.69 w=0.42 l=0.15
X17 a_1129_95# CIN.t0 a_1033_95# x4.VNB sky130_fd_pr__nfet_01v8 ad=0.0441 pd=0.63 as=0.0693 ps=0.75 w=0.42 l=0.15
X18 a_545_n1459# a_491_n1569# a_152_n1851# x4.VNB sky130_fd_pr__nfet_01v8 ad=0.06195 pd=0.715 as=0.0693 ps=0.75 w=0.42 l=0.15
X19 x3.CIN a_491_n289# VGND.t11 x4.VNB sky130_fd_pr__nfet_01v8 ad=0.169 pd=1.82 as=0.10235 ps=0.995 w=0.65 l=0.15
X20 VGND.t5 A0.t0 a_1201_95# x4.VNB sky130_fd_pr__nfet_01v8 ad=0.10235 pd=0.995 as=0.0693 ps=0.75 w=0.42 l=0.15
X21 a_114_247# B0.t7 a_246_461# x1.VPB sky130_fd_pr__pfet_01v8_hvt ad=0.0567 pd=0.69 as=0.063 ps=0.72 w=0.42 l=0.15
X22 VGND.t32 A2.t0 a_1201_n1185# x4.VNB sky130_fd_pr__nfet_01v8 ad=0.10235 pd=0.995 as=0.0693 ps=0.75 w=0.42 l=0.15
X23 a_1201_461# B0.t4 a_1129_461# x1.VPB sky130_fd_pr__pfet_01v8_hvt ad=0.0693 pd=0.75 as=0.0441 ps=0.63 w=0.42 l=0.15
X24 VGND.t7 a_114_247# x2.CIN x4.VNB sky130_fd_pr__nfet_01v8 ad=0.10235 pd=0.995 as=0.169 ps=1.82 w=0.65 l=0.15
X25 VPWR.t32 B1.t1 a_908_n545# x3.VPB sky130_fd_pr__pfet_01v8_hvt ad=0.0567 pd=0.69 as=0.1092 ps=1.36 w=0.42 l=0.15
X26 a_545_n179# a_491_n289# a_152_n571# x4.VNB sky130_fd_pr__nfet_01v8 ad=0.06195 pd=0.715 as=0.0693 ps=0.75 w=0.42 l=0.15
X27 VPWR.t2 A0.t4 a_1201_461# x1.VPB sky130_fd_pr__pfet_01v8_hvt ad=0.14785 pd=1.345 as=0.0693 ps=0.75 w=0.42 l=0.15
X28 a_246_n819# A2.t7 VPWR.t31 x3.VPB sky130_fd_pr__pfet_01v8_hvt ad=0.063 pd=0.72 as=0.14785 ps=1.345 w=0.42 l=0.15
X29 a_246_461# A0.t7 VPWR.t5 x1.VPB sky130_fd_pr__pfet_01v8_hvt ad=0.063 pd=0.72 as=0.14785 ps=1.345 w=0.42 l=0.15
X30 a_377_n1825# B3.t3 a_281_n1825# x4.VPB sky130_fd_pr__pfet_01v8_hvt ad=0.0441 pd=0.63 as=0.0693 ps=0.75 w=0.42 l=0.15
X31 a_1242_n179# B1.t4 a_491_n289# x4.VNB sky130_fd_pr__nfet_01v8 ad=0.063 pd=0.72 as=0.0567 ps=0.69 w=0.42 l=0.15
X32 a_776_95# B0.t1 VGND.t1 x4.VNB sky130_fd_pr__nfet_01v8 ad=0.0567 pd=0.69 as=0.1092 ps=1.36 w=0.42 l=0.15
X33 a_1242_n1459# B3.t4 a_491_n1569# x4.VNB sky130_fd_pr__nfet_01v8 ad=0.063 pd=0.72 as=0.0567 ps=0.69 w=0.42 l=0.15
X34 a_152_n1851# VGND.t41 a_377_n1825# x4.VPB sky130_fd_pr__pfet_01v8_hvt ad=0.0693 pd=0.75 as=0.0441 ps=0.63 w=0.42 l=0.15
X35 a_776_95# A0.t1 VGND.t6 x4.VNB sky130_fd_pr__nfet_01v8 ad=0.06195 pd=0.715 as=0.0567 ps=0.69 w=0.42 l=0.15
X36 a_114_n1033# B2.t7 a_246_n819# x3.VPB sky130_fd_pr__pfet_01v8_hvt ad=0.0567 pd=0.69 as=0.063 ps=0.72 w=0.42 l=0.15
X37 a_377_n179# B1.t7 a_281_n179# x4.VNB sky130_fd_pr__nfet_01v8 ad=0.0441 pd=0.63 as=0.0693 ps=0.75 w=0.42 l=0.15
X38 VPWR.t34 B3.t1 a_908_n1825# x4.VPB sky130_fd_pr__pfet_01v8_hvt ad=0.0567 pd=0.69 as=0.1092 ps=1.36 w=0.42 l=0.15
X39 a_545_n545# x2.CIN VPWR.t13 x3.VPB sky130_fd_pr__pfet_01v8_hvt ad=0.0567 pd=0.69 as=0.0567 ps=0.69 w=0.42 l=0.15
X40 a_908_n1825# A3.t1 VPWR.t23 x4.VPB sky130_fd_pr__pfet_01v8_hvt ad=0.0567 pd=0.69 as=0.0567 ps=0.69 w=0.42 l=0.15
X41 VGND.t24 A1.t4 a_1242_n179# x4.VNB sky130_fd_pr__nfet_01v8 ad=0.10235 pd=0.995 as=0.063 ps=0.72 w=0.42 l=0.15
X42 a_491_n1569# VGND.t42 a_908_n1459# x4.VNB sky130_fd_pr__nfet_01v8 ad=0.0567 pd=0.69 as=0.0567 ps=0.69 w=0.42 l=0.15
X43 a_1033_n1185# a_114_n1033# a_776_n819# x3.VPB sky130_fd_pr__pfet_01v8_hvt ad=0.0693 pd=0.75 as=0.06195 ps=0.715 w=0.42 l=0.15
X44 a_908_n179# A1.t5 VGND.t21 x4.VNB sky130_fd_pr__nfet_01v8 ad=0.0567 pd=0.69 as=0.0567 ps=0.69 w=0.42 l=0.15
X45 VGND.t14 a_152_n1851# S3.t0 x4.VNB sky130_fd_pr__nfet_01v8 ad=0.10235 pd=0.995 as=0.169 ps=1.82 w=0.65 l=0.15
X46 a_420_95# CIN.t2 a_114_247# x4.VNB sky130_fd_pr__nfet_01v8 ad=0.0567 pd=0.69 as=0.0567 ps=0.69 w=0.42 l=0.15
X47 a_545_n1825# a_491_n1569# a_152_n1851# x4.VPB sky130_fd_pr__pfet_01v8_hvt ad=0.06195 pd=0.715 as=0.0693 ps=0.75 w=0.42 l=0.15
X48 a_545_n545# a_491_n289# a_152_n571# x3.VPB sky130_fd_pr__pfet_01v8_hvt ad=0.06195 pd=0.715 as=0.0693 ps=0.75 w=0.42 l=0.15
X49 S2.t0 a_1033_n1185# VGND.t18 x4.VNB sky130_fd_pr__nfet_01v8 ad=0.169 pd=1.82 as=0.10235 ps=0.995 w=0.65 l=0.15
X50 a_1129_461# CIN.t3 a_1033_95# x1.VPB sky130_fd_pr__pfet_01v8_hvt ad=0.0441 pd=0.63 as=0.0693 ps=0.75 w=0.42 l=0.15
X51 VGND.t28 A3.t4 a_1242_n1459# x4.VNB sky130_fd_pr__nfet_01v8 ad=0.10235 pd=0.995 as=0.063 ps=0.72 w=0.42 l=0.15
X52 a_152_n571# x2.CIN a_377_n179# x4.VNB sky130_fd_pr__nfet_01v8 ad=0.0693 pd=0.75 as=0.0441 ps=0.63 w=0.42 l=0.15
X53 a_1242_n545# B1.t0 a_491_n289# x3.VPB sky130_fd_pr__pfet_01v8_hvt ad=0.063 pd=0.72 as=0.0567 ps=0.69 w=0.42 l=0.15
X54 VGND.t37 B3.t6 a_545_n1459# x4.VNB sky130_fd_pr__nfet_01v8 ad=0.1092 pd=1.36 as=0.0567 ps=0.69 w=0.42 l=0.15
X55 a_1242_n1825# B3.t0 a_491_n1569# x4.VPB sky130_fd_pr__pfet_01v8_hvt ad=0.063 pd=0.72 as=0.0567 ps=0.69 w=0.42 l=0.15
X56 VPWR.t30 A2.t6 a_420_n819# x3.VPB sky130_fd_pr__pfet_01v8_hvt ad=0.0567 pd=0.69 as=0.0567 ps=0.69 w=0.42 l=0.15
X57 a_377_n545# B1.t3 a_281_n545# x3.VPB sky130_fd_pr__pfet_01v8_hvt ad=0.0441 pd=0.63 as=0.0693 ps=0.75 w=0.42 l=0.15
X58 COUT.t0 a_491_n1569# VGND.t13 x4.VNB sky130_fd_pr__nfet_01v8 ad=0.169 pd=1.82 as=0.10235 ps=0.995 w=0.65 l=0.15
X59 a_491_n1569# VGND.t39 a_908_n1825# x4.VPB sky130_fd_pr__pfet_01v8_hvt ad=0.0567 pd=0.69 as=0.0567 ps=0.69 w=0.42 l=0.15
X60 a_545_n1459# VGND.t19 VGND.t20 x4.VNB sky130_fd_pr__nfet_01v8 ad=0.0567 pd=0.69 as=0.0567 ps=0.69 w=0.42 l=0.15
X61 a_1201_n819# B2.t4 a_1129_n819# x3.VPB sky130_fd_pr__pfet_01v8_hvt ad=0.0693 pd=0.75 as=0.0441 ps=0.63 w=0.42 l=0.15
X62 VPWR.t18 A1.t0 a_1242_n545# x3.VPB sky130_fd_pr__pfet_01v8_hvt ad=0.14785 pd=1.345 as=0.063 ps=0.72 w=0.42 l=0.15
X63 x3.CIN a_491_n289# VPWR.t8 x3.VPB sky130_fd_pr__pfet_01v8_hvt ad=0.26 pd=2.52 as=0.14785 ps=1.345 w=1 l=0.15
X64 a_908_n545# A1.t1 VPWR.t19 x3.VPB sky130_fd_pr__pfet_01v8_hvt ad=0.0567 pd=0.69 as=0.0567 ps=0.69 w=0.42 l=0.15
X65 VGND.t22 A1.t6 a_545_n179# x4.VNB sky130_fd_pr__nfet_01v8 ad=0.0567 pd=0.69 as=0.06195 ps=0.715 w=0.42 l=0.15
X66 a_114_247# B0.t3 a_246_95# x4.VNB sky130_fd_pr__nfet_01v8 ad=0.0567 pd=0.69 as=0.063 ps=0.72 w=0.42 l=0.15
X67 VGND.t17 x3.CIN a_776_n1185# x4.VNB sky130_fd_pr__nfet_01v8 ad=0.0567 pd=0.69 as=0.0567 ps=0.69 w=0.42 l=0.15
X68 a_420_n1185# x3.CIN a_114_n1033# x4.VNB sky130_fd_pr__nfet_01v8 ad=0.0567 pd=0.69 as=0.0567 ps=0.69 w=0.42 l=0.15
X69 VPWR.t22 A3.t0 a_1242_n1825# x4.VPB sky130_fd_pr__pfet_01v8_hvt ad=0.14785 pd=1.345 as=0.063 ps=0.72 w=0.42 l=0.15
X70 VGND.t10 a_114_n1033# VGND.t9 x4.VNB sky130_fd_pr__nfet_01v8 ad=0.169 pd=1.82 as=0 ps=0 w=0.65 l=0.15
X71 a_152_n571# x2.CIN a_377_n545# x3.VPB sky130_fd_pr__pfet_01v8_hvt ad=0.0693 pd=0.75 as=0.0441 ps=0.63 w=0.42 l=0.15
X72 a_776_n1185# B2.t1 VGND.t29 x4.VNB sky130_fd_pr__nfet_01v8 ad=0.0567 pd=0.69 as=0.1092 ps=1.36 w=0.42 l=0.15
X73 VGND.t12 a_152_n571# S1.t0 x4.VNB sky130_fd_pr__nfet_01v8 ad=0.10235 pd=0.995 as=0.169 ps=1.82 w=0.65 l=0.15
X74 VGND.t4 A0.t2 a_420_95# x4.VNB sky130_fd_pr__nfet_01v8 ad=0.0567 pd=0.69 as=0.0567 ps=0.69 w=0.42 l=0.15
X75 VPWR.t35 B3.t2 a_545_n1825# x4.VPB sky130_fd_pr__pfet_01v8_hvt ad=0.1092 pd=1.36 as=0.0567 ps=0.69 w=0.42 l=0.15
X76 VGND.t25 A3.t6 a_545_n1459# x4.VNB sky130_fd_pr__nfet_01v8 ad=0.0567 pd=0.69 as=0.06195 ps=0.715 w=0.42 l=0.15
X77 a_1033_95# a_114_247# a_776_461# x1.VPB sky130_fd_pr__pfet_01v8_hvt ad=0.0693 pd=0.75 as=0.06195 ps=0.715 w=0.42 l=0.15
X78 a_491_n289# x2.CIN a_908_n179# x4.VNB sky130_fd_pr__nfet_01v8 ad=0.0567 pd=0.69 as=0.0567 ps=0.69 w=0.42 l=0.15
X79 a_420_461# B0.t6 VPWR.t1 x1.VPB sky130_fd_pr__pfet_01v8_hvt ad=0.1092 pd=1.36 as=0.0567 ps=0.69 w=0.42 l=0.15
X80 VPWR.t12 a_152_n1851# S3.t1 x4.VPB sky130_fd_pr__pfet_01v8_hvt ad=0.14785 pd=1.345 as=0.26 ps=2.52 w=1 l=0.15
X81 a_545_n1825# VGND.t40 VPWR.t17 x4.VPB sky130_fd_pr__pfet_01v8_hvt ad=0.0567 pd=0.69 as=0.0567 ps=0.69 w=0.42 l=0.15
X82 a_281_n1459# A3.t7 VGND.t26 x4.VNB sky130_fd_pr__nfet_01v8 ad=0.0693 pd=0.75 as=0.10235 ps=0.995 w=0.42 l=0.15
X83 VGND.t36 B1.t6 a_545_n179# x4.VNB sky130_fd_pr__nfet_01v8 ad=0.1092 pd=1.36 as=0.0567 ps=0.69 w=0.42 l=0.15
X84 VPWR.t15 x3.CIN a_776_n819# x3.VPB sky130_fd_pr__pfet_01v8_hvt ad=0.0567 pd=0.69 as=0.0567 ps=0.69 w=0.42 l=0.15
X85 VPWR.t20 A1.t2 a_545_n545# x3.VPB sky130_fd_pr__pfet_01v8_hvt ad=0.0567 pd=0.69 as=0.06195 ps=0.715 w=0.42 l=0.15
X86 VPWR.t4 A0.t6 a_420_461# x1.VPB sky130_fd_pr__pfet_01v8_hvt ad=0.0567 pd=0.69 as=0.0567 ps=0.69 w=0.42 l=0.15
X87 S2.t1 a_1033_n1185# VPWR.t16 x3.VPB sky130_fd_pr__pfet_01v8_hvt ad=0.26 pd=2.52 as=0.14785 ps=1.345 w=1 l=0.15
X88 VGND.t34 A2.t2 a_420_n1185# x4.VNB sky130_fd_pr__nfet_01v8 ad=0.0567 pd=0.69 as=0.0567 ps=0.69 w=0.42 l=0.15
X89 a_281_n179# A1.t7 VGND.t23 x4.VNB sky130_fd_pr__nfet_01v8 ad=0.0693 pd=0.75 as=0.10235 ps=0.995 w=0.42 l=0.15
X90 a_776_n1185# A2.t1 VGND.t31 x4.VNB sky130_fd_pr__nfet_01v8 ad=0.06195 pd=0.715 as=0.0567 ps=0.69 w=0.42 l=0.15
X91 a_1033_95# a_114_247# a_776_95# x4.VNB sky130_fd_pr__nfet_01v8 ad=0.0693 pd=0.75 as=0.06195 ps=0.715 w=0.42 l=0.15
X92 a_776_461# A0.t5 VPWR.t3 x1.VPB sky130_fd_pr__pfet_01v8_hvt ad=0.06195 pd=0.715 as=0.0567 ps=0.69 w=0.42 l=0.15
X93 a_420_n819# B2.t6 VPWR.t27 x3.VPB sky130_fd_pr__pfet_01v8_hvt ad=0.1092 pd=1.36 as=0.0567 ps=0.69 w=0.42 l=0.15
X94 COUT.t1 a_491_n1569# VPWR.t11 x4.VPB sky130_fd_pr__pfet_01v8_hvt ad=0.26 pd=2.52 as=0.14785 ps=1.345 w=1 l=0.15
X95 a_246_n1185# A2.t3 VGND.t33 x4.VNB sky130_fd_pr__nfet_01v8 ad=0.063 pd=0.72 as=0.10235 ps=0.995 w=0.42 l=0.15
X96 a_420_461# CIN.t5 a_114_247# x1.VPB sky130_fd_pr__pfet_01v8_hvt ad=0.0567 pd=0.69 as=0.0567 ps=0.69 w=0.42 l=0.15
X97 VPWR.t24 A3.t2 a_545_n1825# x4.VPB sky130_fd_pr__pfet_01v8_hvt ad=0.0567 pd=0.69 as=0.06195 ps=0.715 w=0.42 l=0.15
X98 a_1201_95# B0.t0 a_1129_95# x4.VNB sky130_fd_pr__nfet_01v8 ad=0.0693 pd=0.75 as=0.0441 ps=0.63 w=0.42 l=0.15
X99 a_1201_n1185# B2.t0 a_1129_n1185# x4.VNB sky130_fd_pr__nfet_01v8 ad=0.0693 pd=0.75 as=0.0441 ps=0.63 w=0.42 l=0.15
X100 a_491_n289# x2.CIN a_908_n545# x3.VPB sky130_fd_pr__pfet_01v8_hvt ad=0.0567 pd=0.69 as=0.0567 ps=0.69 w=0.42 l=0.15
X101 VPWR.t10 CIN.t4 a_776_461# x1.VPB sky130_fd_pr__pfet_01v8_hvt ad=0.0567 pd=0.69 as=0.0567 ps=0.69 w=0.42 l=0.15
X102 a_420_95# B0.t2 VGND.t2 x4.VNB sky130_fd_pr__nfet_01v8 ad=0.1092 pd=1.36 as=0.0567 ps=0.69 w=0.42 l=0.15
X103 a_281_n1825# A3.t3 VPWR.t25 x4.VPB sky130_fd_pr__pfet_01v8_hvt ad=0.0693 pd=0.75 as=0.14785 ps=1.345 w=0.42 l=0.15
X104 VPWR.t33 B1.t2 a_545_n545# x3.VPB sky130_fd_pr__pfet_01v8_hvt ad=0.1092 pd=1.36 as=0.0567 ps=0.69 w=0.42 l=0.15
X105 VPWR.t7 a_114_n1033# VGND.t8 x3.VPB sky130_fd_pr__pfet_01v8_hvt ad=0.14785 pd=1.345 as=0.26 ps=2.52 w=1 l=0.15
X106 VPWR.t9 a_152_n571# S1.t1 x3.VPB sky130_fd_pr__pfet_01v8_hvt ad=0.14785 pd=1.345 as=0.26 ps=2.52 w=1 l=0.15
X107 a_281_n545# A1.t3 VPWR.t21 x3.VPB sky130_fd_pr__pfet_01v8_hvt ad=0.0693 pd=0.75 as=0.14785 ps=1.345 w=0.42 l=0.15
X108 a_114_n1033# B2.t3 a_246_n1185# x4.VNB sky130_fd_pr__nfet_01v8 ad=0.0567 pd=0.69 as=0.063 ps=0.72 w=0.42 l=0.15
X109 a_420_n1185# B2.t2 VGND.t30 x4.VNB sky130_fd_pr__nfet_01v8 ad=0.1092 pd=1.36 as=0.0567 ps=0.69 w=0.42 l=0.15
X110 S0.t0 a_1033_95# VGND.t16 x4.VNB sky130_fd_pr__nfet_01v8 ad=0.169 pd=1.82 as=0.10235 ps=0.995 w=0.65 l=0.15
X111 a_776_461# B0.t5 VPWR.t0 x1.VPB sky130_fd_pr__pfet_01v8_hvt ad=0.0567 pd=0.69 as=0.1092 ps=1.36 w=0.42 l=0.15
R0 COUT.n2 COUT.t1 782
R1 COUT.t1 COUT.n1 744.115
R2 COUT COUT.t0 211.647
R3 COUT.n1 COUT 73.7552
R4 COUT COUT.n2 14.2774
R5 COUT.n0 COUT 14.1052
R6 COUT.n1 COUT.n0 4.92358
R7 COUT COUT.n0 3.93896
R8 COUT.n2 COUT 2.46204
R9 S3.n4 S3.t1 755.481
R10 S3.t1 S3.n3 755.481
R11 S3 S3.t0 211.043
R12 S3.n2 S3 9.76367
R13 S3.n3 S3 8.1605
R14 S3.n1 S3 8.14595
R15 S3.n0 S3 6.8805
R16 S3.n4 S3 6.2405
R17 S3.n1 S3 5.04292
R18 S3 S3.n0 4.84898
R19 S3 S3.n4 4.6405
R20 S3.n0 S3 4.0005
R21 S3 S3.n2 2.7205
R22 S3.n3 S3 2.7205
R23 S3.n2 S3.n1 1.4405
R24 B3.n10 B3.t4 384.529
R25 B3.n0 B3.t7 373.283
R26 B3.n4 B3.t5 351.861
R27 B3.n5 B3.t1 297.233
R28 B3.n6 B3.n4 214.362
R29 B3.n0 B3.t3 167.63
R30 B3.n11 B3.n10 158.768
R31 B3.n10 B3.t0 156.382
R32 B3.n7 B3.n6 152
R33 B3.n1 B3.n0 152
R34 B3.n4 B3.t6 109.215
R35 B3.n5 B3.t2 102.779
R36 B3.n6 B3.n5 47.4474
R37 B3.n8 B3.n7 11.7894
R38 B3.n2 B3.n1 10.3005
R39 B3.n1 B3 10.2005
R40 B3.n12 B3.n11 9.3005
R41 B3.n7 B3 5.86717
R42 B3.n11 B3 2.50165
R43 B3.n9 B3 2.313
R44 B3 B3.n3 1.79514
R45 B3 B3.n9 1.40229
R46 B3.n12 B3 1.39962
R47 B3.n3 B3 0.259429
R48 B3.n3 B3.n2 0.0793043
R49 B3.n2 B3 0.0793043
R50 B3.n9 B3.n8 0.0793043
R51 B3.n8 B3 0.0793043
R52 B3 B3.n12 0.0793043
R53 A3.n4 A3.t2 373.283
R54 A3.n0 A3.t3 347.577
R55 A3.n12 A3.t0 334.723
R56 A3.n8 A3.t1 323.476
R57 A3.n8 A3.t5 217.436
R58 A3.n12 A3.t4 206.19
R59 A3.n0 A3.t7 193.337
R60 A3.n4 A3.t6 167.63
R61 A3.n9 A3.n8 160.534
R62 A3.n13 A3.n12 159.315
R63 A3.n5 A3.n4 157.12
R64 A3.n1 A3.n0 156
R65 A3.n2 A3.n1 9.3005
R66 A3.n6 A3.n5 9.3005
R67 A3.n10 A3.n9 9.3005
R68 A3.n14 A3.n13 9.3005
R69 A3.n1 A3 4.8005
R70 A3.n13 A3 3.88621
R71 A3.n11 A3 3.563
R72 A3.n9 A3 3.29747
R73 A3.n5 A3 2.90183
R74 A3.n7 A3 1.90229
R75 A3 A3.n7 1.40229
R76 A3 A3.n3 1.38443
R77 A3.n14 A3 1.04024
R78 A3 A3.n11 0.973714
R79 A3.n3 A3 0.259429
R80 A3.n3 A3.n2 0.0793043
R81 A3.n2 A3 0.0793043
R82 A3.n7 A3.n6 0.0793043
R83 A3.n6 A3 0.0793043
R84 A3.n11 A3.n10 0.0793043
R85 A3.n10 A3 0.0793043
R86 A3 A3.n14 0.0793043
R87 S2.t1 S2 758.202
R88 S2.n2 S2.t1 755.481
R89 S2.n0 S2.t0 209.923
R90 S2 S2.n1 11.4429
R91 S2.n3 S2 9.64866
R92 S2.n3 S2.n2 7.2005
R93 S2 S2.n0 6.5605
R94 S2.n0 S2 4.3205
R95 S2.n1 S2 1.74595
R96 S2.n4 S2.n3 1.6005
R97 S2.n4 S2 1.55202
R98 S2.n1 S2 1.4405
R99 S2 S2.n4 1.2805
R100 S2.n2 S2 0.8005
R101 B2.n9 B2.t3 384.529
R102 B2.n0 B2.t0 373.283
R103 B2.n4 B2.t2 351.861
R104 B2.n3 B2.t6 297.233
R105 B2.n5 B2.n4 214.362
R106 B2.n0 B2.t4 167.63
R107 B2.n10 B2.n9 157.921
R108 B2.n1 B2.n0 156.571
R109 B2.n9 B2.t7 156.382
R110 B2.n6 B2.n5 152
R111 B2.n4 B2.t1 109.215
R112 B2.n3 B2.t5 102.659
R113 B2.n5 B2.n3 47.4474
R114 B2.n7 B2.n6 10.2702
R115 B2.n6 B2 9.69747
R116 B2 B2.n1 9.37931
R117 B2.n11 B2.n10 9.3005
R118 B2.n10 B2 2.7205
R119 B2.n1 B2 2.59098
R120 B2.n2 B2 1.92014
R121 B2.n2 B2 1.79514
R122 B2.n8 B2 1.40229
R123 B2.n8 B2 0.259429
R124 B2.n7 B2.n2 0.0793043
R125 B2 B2.n7 0.0793043
R126 B2.n11 B2.n8 0.0793043
R127 B2 B2.n11 0.0793043
R128 A2.n3 A2.t5 373.283
R129 A2.n0 A2.t4 347.577
R130 A2.n11 A2.t7 334.723
R131 A2.n7 A2.t6 323.476
R132 A2.n7 A2.t2 217.436
R133 A2.n11 A2.t3 206.19
R134 A2.n0 A2.t0 193.337
R135 A2.n3 A2.t1 167.63
R136 A2.n12 A2.n11 152
R137 A2.n8 A2.n7 152
R138 A2.n4 A2.n3 152
R139 A2.n1 A2.n0 152
R140 A2.n9 A2.n8 17.8338
R141 A2.n1 A2 14.6672
R142 A2.n5 A2.n4 14.4205
R143 A2 A2.n1 13.3793
R144 A2.n13 A2.n12 10.4641
R145 A2.n8 A2 3.29747
R146 A2.n2 A2 3.15229
R147 A2.n4 A2 2.90183
R148 A2.n12 A2 2.13383
R149 A2.n6 A2 1.49157
R150 A2.n6 A2 1.40229
R151 A2.n2 A2 1.38443
R152 A2.n10 A2 0.973714
R153 A2.n10 A2 0.259429
R154 A2.n5 A2.n2 0.0793043
R155 A2 A2.n5 0.0793043
R156 A2.n9 A2.n6 0.0793043
R157 A2 A2.n9 0.0793043
R158 A2.n13 A2.n10 0.0793043
R159 A2 A2.n13 0.0793043
R160 S1.n4 S1.t1 755.481
R161 S1.t1 S1.n3 755.481
R162 S1 S1.t0 211.043
R163 S1.n2 S1 9.68141
R164 S1.n3 S1 8.1605
R165 S1.n1 S1 8.14595
R166 S1.n0 S1 6.8805
R167 S1.n4 S1 6.2405
R168 S1.n1 S1 5.04292
R169 S1 S1.n0 4.84898
R170 S1 S1.n4 4.6405
R171 S1.n0 S1 4.0005
R172 S1 S1.n2 2.7205
R173 S1.n3 S1 2.7205
R174 S1.n2 S1.n1 1.4405
R175 B1.n10 B1.t4 384.529
R176 B1.n0 B1.t7 373.283
R177 B1.n4 B1.t5 351.861
R178 B1.n5 B1.t1 297.233
R179 B1.n6 B1.n4 214.362
R180 B1.n0 B1.t3 167.63
R181 B1.n11 B1.n10 158.768
R182 B1.n10 B1.t0 156.382
R183 B1.n7 B1.n6 152
R184 B1.n1 B1.n0 152
R185 B1.n4 B1.t6 109.215
R186 B1.n5 B1.t2 102.779
R187 B1.n6 B1.n5 47.4474
R188 B1.n8 B1.n7 11.7894
R189 B1.n2 B1.n1 10.3005
R190 B1.n1 B1 10.2005
R191 B1.n12 B1.n11 9.3005
R192 B1.n7 B1 5.86717
R193 B1.n11 B1 2.50165
R194 B1.n9 B1 2.313
R195 B1 B1.n3 1.79514
R196 B1 B1.n9 1.40229
R197 B1.n12 B1 1.3146
R198 B1.n3 B1 0.259429
R199 B1.n3 B1.n2 0.0793043
R200 B1.n2 B1 0.0793043
R201 B1.n9 B1.n8 0.0793043
R202 B1.n8 B1 0.0793043
R203 B1 B1.n12 0.0793043
R204 A1.n4 A1.t2 373.283
R205 A1.n0 A1.t3 347.577
R206 A1.n12 A1.t0 334.723
R207 A1.n8 A1.t1 323.476
R208 A1.n8 A1.t5 217.436
R209 A1.n12 A1.t4 206.19
R210 A1.n0 A1.t7 193.337
R211 A1.n4 A1.t6 167.63
R212 A1.n9 A1.n8 160.534
R213 A1.n13 A1.n12 159.315
R214 A1.n5 A1.n4 157.12
R215 A1.n1 A1.n0 156
R216 A1.n2 A1.n1 9.3005
R217 A1.n6 A1.n5 9.3005
R218 A1.n10 A1.n9 9.3005
R219 A1.n14 A1.n13 9.3005
R220 A1.n1 A1 4.8005
R221 A1.n13 A1 3.88621
R222 A1.n11 A1 3.563
R223 A1.n9 A1 3.29747
R224 A1.n5 A1 2.90183
R225 A1.n7 A1 1.90229
R226 A1 A1.n7 1.40229
R227 A1 A1.n3 1.38443
R228 A1 A1.n11 0.973714
R229 A1.n14 A1 0.96901
R230 A1.n3 A1 0.259429
R231 A1.n3 A1.n2 0.0793043
R232 A1.n2 A1 0.0793043
R233 A1.n7 A1.n6 0.0793043
R234 A1.n6 A1 0.0793043
R235 A1.n11 A1.n10 0.0793043
R236 A1.n10 A1 0.0793043
R237 A1 A1.n14 0.0793043
R238 S0.t1 S0 758.202
R239 S0.n2 S0.t1 755.481
R240 S0.n0 S0.t0 209.923
R241 S0 S0.n1 11.4429
R242 S0.n3 S0 9.65237
R243 S0.n3 S0.n2 7.5205
R244 S0 S0.n0 6.5605
R245 S0.n0 S0 4.3205
R246 S0.n1 S0 1.74595
R247 S0.n4 S0 1.55202
R248 S0.n1 S0 1.4405
R249 S0.n4 S0.n3 1.2805
R250 S0 S0.n4 1.2805
R251 S0.n2 S0 0.8005
R252 VGND.t8 VGND 787.909
R253 VGND.n15 VGND.t8 744.115
R254 VGND.n21 VGND.t43 373.283
R255 VGND.n20 VGND.n18 357.442
R256 VGND.n19 VGND.t19 346.022
R257 VGND.n18 VGND.t39 325.082
R258 VGND.n31 VGND.t29 239.281
R259 VGND.n97 VGND.t37 239.281
R260 VGND.n73 VGND.t1 239.281
R261 VGND.n75 VGND.t36 239.281
R262 VGND.n18 VGND.t42 215.829
R263 VGND.n16 VGND.t10 209.923
R264 VGND.n124 VGND.n2 199.739
R265 VGND.n42 VGND.n41 199.739
R266 VGND.n6 VGND.n5 199.739
R267 VGND.n65 VGND.n60 199.739
R268 VGND.n47 VGND.n46 198.964
R269 VGND.n94 VGND.n92 198.964
R270 VGND.n103 VGND.n102 198.964
R271 VGND.n27 VGND.n26 198.964
R272 VGND.n99 VGND.n34 198.964
R273 VGND.n37 VGND.n36 198.964
R274 VGND.n62 VGND.n61 198.964
R275 VGND.n84 VGND.n72 198.964
R276 VGND.n112 VGND.n12 198.964
R277 VGND.n119 VGND.n8 198.964
R278 VGND.n77 VGND.n76 198.964
R279 VGND.n55 VGND.n54 198.964
R280 VGND.n19 VGND.t40 193.337
R281 VGND.n21 VGND.t41 167.63
R282 VGND.n20 VGND.n19 152
R283 VGND.n22 VGND.n21 152
R284 VGND.n22 VGND.n20 88.4259
R285 VGND.n16 VGND.n15 75.4783
R286 VGND.n2 VGND.t33 60.0005
R287 VGND.n41 VGND.t28 60.0005
R288 VGND.n5 VGND.t3 60.0005
R289 VGND.n60 VGND.t24 60.0005
R290 VGND.n46 VGND.t18 46.8576
R291 VGND.n26 VGND.t14 46.8576
R292 VGND.n61 VGND.t16 46.8576
R293 VGND.n8 VGND.t12 46.8576
R294 VGND.n45 VGND.n44 43.9358
R295 VGND.n64 VGND.n63 43.9358
R296 VGND.n46 VGND.t32 38.5719
R297 VGND.n92 VGND.t31 38.5719
R298 VGND.n92 VGND.t17 38.5719
R299 VGND.n102 VGND.t30 38.5719
R300 VGND.n102 VGND.t34 38.5719
R301 VGND.n26 VGND.t26 38.5719
R302 VGND.n34 VGND.t20 38.5719
R303 VGND.n34 VGND.t25 38.5719
R304 VGND.n36 VGND.t27 38.5719
R305 VGND.n36 VGND.t38 38.5719
R306 VGND.n61 VGND.t5 38.5719
R307 VGND.n72 VGND.t6 38.5719
R308 VGND.n72 VGND.t0 38.5719
R309 VGND.n12 VGND.t2 38.5719
R310 VGND.n12 VGND.t4 38.5719
R311 VGND.n8 VGND.t23 38.5719
R312 VGND.n76 VGND.t15 38.5719
R313 VGND.n76 VGND.t22 38.5719
R314 VGND.n54 VGND.t21 38.5719
R315 VGND.n54 VGND.t35 38.5719
R316 VGND.n48 VGND.n39 34.6358
R317 VGND.n90 VGND.n39 34.6358
R318 VGND.n91 VGND.n90 34.6358
R319 VGND.n105 VGND.n104 34.6358
R320 VGND.n104 VGND.n1 34.6358
R321 VGND.n33 VGND.n25 34.6358
R322 VGND.n29 VGND.n25 34.6358
R323 VGND.n29 VGND.n28 34.6358
R324 VGND.n51 VGND.n50 34.6358
R325 VGND.n52 VGND.n51 34.6358
R326 VGND.n70 VGND.n57 34.6358
R327 VGND.n71 VGND.n70 34.6358
R328 VGND.n85 VGND.n71 34.6358
R329 VGND.n115 VGND.n113 34.6358
R330 VGND.n115 VGND.n114 34.6358
R331 VGND.n14 VGND.n9 34.6358
R332 VGND.n117 VGND.n9 34.6358
R333 VGND.n118 VGND.n117 34.6358
R334 VGND.n68 VGND.n66 34.6358
R335 VGND.n68 VGND.n67 34.6358
R336 VGND.n94 VGND.n91 31.624
R337 VGND.n99 VGND.n33 31.624
R338 VGND.n85 VGND.n84 31.624
R339 VGND.n77 VGND.n14 31.624
R340 VGND.n125 VGND.n124 30.7593
R341 VGND.n44 VGND.n42 30.7593
R342 VGND.n7 VGND.n6 30.7593
R343 VGND.n65 VGND.n64 30.7593
R344 VGND.n103 VGND.n101 27.1064
R345 VGND.n96 VGND.n37 27.1064
R346 VGND.n112 VGND.n11 27.1064
R347 VGND.n74 VGND.n55 27.1064
R348 VGND.n93 VGND.n31 25.6005
R349 VGND.n98 VGND.n97 25.6005
R350 VGND.n83 VGND.n73 25.6005
R351 VGND.n78 VGND.n75 25.6005
R352 VGND.n2 VGND.t9 25.4291
R353 VGND.n41 VGND.t13 25.4291
R354 VGND.n5 VGND.t7 25.4291
R355 VGND.n60 VGND.t11 25.4291
R356 VGND.n124 VGND.n1 22.9652
R357 VGND.n50 VGND.n42 22.9652
R358 VGND.n114 VGND.n6 22.9652
R359 VGND.n66 VGND.n65 22.9652
R360 VGND.n101 VGND.n31 18.824
R361 VGND.n97 VGND.n96 18.824
R362 VGND.n73 VGND.n11 18.824
R363 VGND.n75 VGND.n74 18.824
R364 VGND.n105 VGND.n103 17.3181
R365 VGND.n52 VGND.n37 17.3181
R366 VGND.n113 VGND.n112 17.3181
R367 VGND.n67 VGND.n55 17.3181
R368 VGND.n81 VGND.n80 16.6607
R369 VGND.n88 VGND.n87 16.6607
R370 VGND.n109 VGND.n17 15.3519
R371 VGND.n108 VGND.n23 15.1821
R372 VGND.n27 VGND.n0 13.3149
R373 VGND.n120 VGND.n119 13.3148
R374 VGND.n94 VGND.n93 12.8005
R375 VGND.n99 VGND.n98 12.8005
R376 VGND.n84 VGND.n83 12.8005
R377 VGND.n78 VGND.n77 12.8005
R378 VGND.n110 VGND.n109 12.1603
R379 VGND.n23 VGND.n22 9.4725
R380 VGND.n65 VGND.n59 9.3005
R381 VGND.n66 VGND.n58 9.3005
R382 VGND.n69 VGND.n68 9.3005
R383 VGND.n67 VGND.n53 9.3005
R384 VGND.n86 VGND.n55 9.3005
R385 VGND.n74 VGND.n56 9.3005
R386 VGND.n82 VGND.n75 9.3005
R387 VGND.n79 VGND.n78 9.3005
R388 VGND.n77 VGND.n13 9.3005
R389 VGND.n111 VGND.n14 9.3005
R390 VGND.n10 VGND.n9 9.3005
R391 VGND.n117 VGND.n116 9.3005
R392 VGND.n118 VGND.n4 9.3005
R393 VGND.n121 VGND.n6 9.3005
R394 VGND.n63 VGND.n59 9.3005
R395 VGND.n58 VGND.n57 9.3005
R396 VGND.n70 VGND.n69 9.3005
R397 VGND.n71 VGND.n53 9.3005
R398 VGND.n86 VGND.n85 9.3005
R399 VGND.n84 VGND.n56 9.3005
R400 VGND.n83 VGND.n82 9.3005
R401 VGND.n79 VGND.n73 9.3005
R402 VGND.n13 VGND.n11 9.3005
R403 VGND.n112 VGND.n111 9.3005
R404 VGND.n113 VGND.n10 9.3005
R405 VGND.n116 VGND.n115 9.3005
R406 VGND.n114 VGND.n4 9.3005
R407 VGND.n43 VGND.n42 9.3005
R408 VGND.n50 VGND.n49 9.3005
R409 VGND.n51 VGND.n40 9.3005
R410 VGND.n89 VGND.n52 9.3005
R411 VGND.n38 VGND.n37 9.3005
R412 VGND.n96 VGND.n95 9.3005
R413 VGND.n97 VGND.n35 9.3005
R414 VGND.n98 VGND.n32 9.3005
R415 VGND.n100 VGND.n99 9.3005
R416 VGND.n33 VGND.n24 9.3005
R417 VGND.n106 VGND.n25 9.3005
R418 VGND.n30 VGND.n29 9.3005
R419 VGND.n28 VGND.n3 9.3005
R420 VGND.n124 VGND.n123 9.3005
R421 VGND.n45 VGND.n43 9.3005
R422 VGND.n49 VGND.n48 9.3005
R423 VGND.n40 VGND.n39 9.3005
R424 VGND.n90 VGND.n89 9.3005
R425 VGND.n91 VGND.n38 9.3005
R426 VGND.n95 VGND.n94 9.3005
R427 VGND.n93 VGND.n35 9.3005
R428 VGND.n32 VGND.n31 9.3005
R429 VGND.n101 VGND.n100 9.3005
R430 VGND.n103 VGND.n24 9.3005
R431 VGND.n106 VGND.n105 9.3005
R432 VGND.n104 VGND.n30 9.3005
R433 VGND.n3 VGND.n1 9.3005
R434 VGND.n123 VGND.n122 8.74901
R435 VGND.n122 VGND.n121 7.91214
R436 VGND.n47 VGND.n45 5.64756
R437 VGND.n63 VGND.n62 5.64756
R438 VGND.n23 VGND 4.6085
R439 VGND.n108 VGND.n107 4.5005
R440 VGND.n17 VGND 4.43127
R441 VGND.n48 VGND.n47 4.14168
R442 VGND.n28 VGND.n27 4.14168
R443 VGND.n62 VGND.n57 4.14168
R444 VGND.n119 VGND.n118 4.14168
R445 VGND.n17 VGND.n16 2.21588
R446 VGND.n64 VGND 0.985882
R447 VGND.n15 VGND 0.492808
R448 VGND.n122 VGND 0.320361
R449 VGND.n59 VGND.n58 0.0597784
R450 VGND.n69 VGND.n58 0.0597784
R451 VGND.n69 VGND.n53 0.0597784
R452 VGND.n86 VGND.n56 0.0597784
R453 VGND.n82 VGND.n56 0.0597784
R454 VGND.n79 VGND.n13 0.0597784
R455 VGND.n111 VGND.n13 0.0597784
R456 VGND.n116 VGND.n10 0.0597784
R457 VGND.n116 VGND.n4 0.0597784
R458 VGND.n121 VGND.n4 0.0597784
R459 VGND.n49 VGND.n43 0.0591735
R460 VGND.n49 VGND.n40 0.0591735
R461 VGND.n89 VGND.n40 0.0591735
R462 VGND.n95 VGND.n38 0.0591735
R463 VGND.n95 VGND.n35 0.0591735
R464 VGND.n100 VGND.n32 0.0591735
R465 VGND.n100 VGND.n24 0.0591735
R466 VGND.n106 VGND.n30 0.0591735
R467 VGND.n30 VGND.n3 0.0591735
R468 VGND.n123 VGND.n3 0.0591735
R469 VGND.n111 VGND.n110 0.0520464
R470 VGND.n107 VGND.n24 0.0515204
R471 VGND.n120 VGND.n7 0.0498682
R472 VGND.n125 VGND.n0 0.0493701
R473 VGND VGND.n59 0.0481804
R474 VGND VGND.n43 0.0476939
R475 VGND.n82 VGND.n81 0.0443144
R476 VGND.n80 VGND.n35 0.0438673
R477 VGND.n87 VGND.n53 0.0365825
R478 VGND.n89 VGND.n88 0.0362143
R479 VGND.n87 VGND.n86 0.0236959
R480 VGND.n88 VGND.n38 0.0234592
R481 VGND.n81 VGND.n79 0.0159639
R482 VGND.n80 VGND.n32 0.0158061
R483 VGND.n64 VGND 0.0120979
R484 VGND.n44 VGND 0.0119796
R485 VGND.n121 VGND.n120 0.0113442
R486 VGND.n123 VGND.n0 0.0112387
R487 VGND.n7 VGND 0.0108093
R488 VGND VGND.n125 0.0107041
R489 VGND.n110 VGND.n10 0.00823196
R490 VGND.n107 VGND.n106 0.00815306
R491 VGND.n109 VGND.n108 0.00214474
R492 VPWR.n104 VPWR.t33 663.062
R493 VPWR.n9 VPWR.t26 663.062
R494 VPWR.n80 VPWR.t0 663.062
R495 VPWR.n38 VPWR.t35 663.062
R496 VPWR.n23 VPWR.n22 605.481
R497 VPWR.n118 VPWR.n117 605.481
R498 VPWR.n59 VPWR.n58 605.481
R499 VPWR.n32 VPWR.n31 605.481
R500 VPWR.n98 VPWR.n97 598.965
R501 VPWR.n107 VPWR.n106 598.965
R502 VPWR.n121 VPWR.n116 598.965
R503 VPWR.n110 VPWR.n8 598.965
R504 VPWR.n101 VPWR.n15 598.965
R505 VPWR.n25 VPWR.n20 598.965
R506 VPWR.n56 VPWR.n55 598.965
R507 VPWR.n54 VPWR.n42 598.965
R508 VPWR.n45 VPWR.n44 598.965
R509 VPWR.n88 VPWR.n37 598.965
R510 VPWR.n72 VPWR.n71 598.965
R511 VPWR.n131 VPWR.n130 598.965
R512 VPWR.n22 VPWR.t18 98.5005
R513 VPWR.n116 VPWR.t21 98.5005
R514 VPWR.n117 VPWR.t31 98.5005
R515 VPWR.n20 VPWR.t28 98.5005
R516 VPWR.n58 VPWR.t5 98.5005
R517 VPWR.n44 VPWR.t2 98.5005
R518 VPWR.n31 VPWR.t22 98.5005
R519 VPWR.n130 VPWR.t25 98.5005
R520 VPWR.n97 VPWR.t19 63.3219
R521 VPWR.n97 VPWR.t32 63.3219
R522 VPWR.n106 VPWR.t13 63.3219
R523 VPWR.n106 VPWR.t20 63.3219
R524 VPWR.n8 VPWR.t27 63.3219
R525 VPWR.n8 VPWR.t30 63.3219
R526 VPWR.n15 VPWR.t29 63.3219
R527 VPWR.n15 VPWR.t15 63.3219
R528 VPWR.n55 VPWR.t1 63.3219
R529 VPWR.n55 VPWR.t4 63.3219
R530 VPWR.n42 VPWR.t3 63.3219
R531 VPWR.n42 VPWR.t10 63.3219
R532 VPWR.n37 VPWR.t23 63.3219
R533 VPWR.n37 VPWR.t34 63.3219
R534 VPWR.n71 VPWR.t17 63.3219
R535 VPWR.n71 VPWR.t24 63.3219
R536 VPWR.n121 VPWR.n120 43.9358
R537 VPWR.n25 VPWR.n21 43.9358
R538 VPWR.n95 VPWR.n18 34.6358
R539 VPWR.n96 VPWR.n95 34.6358
R540 VPWR.n114 VPWR.n6 34.6358
R541 VPWR.n115 VPWR.n114 34.6358
R542 VPWR.n122 VPWR.n115 34.6358
R543 VPWR.n112 VPWR.n111 34.6358
R544 VPWR.n111 VPWR.n4 34.6358
R545 VPWR.n27 VPWR.n26 34.6358
R546 VPWR.n27 VPWR.n16 34.6358
R547 VPWR.n100 VPWR.n16 34.6358
R548 VPWR.n65 VPWR.n64 34.6358
R549 VPWR.n64 VPWR.n63 34.6358
R550 VPWR.n49 VPWR.n43 34.6358
R551 VPWR.n50 VPWR.n49 34.6358
R552 VPWR.n53 VPWR.n50 34.6358
R553 VPWR.n36 VPWR.n35 34.6358
R554 VPWR.n89 VPWR.n36 34.6358
R555 VPWR.n73 VPWR.n1 34.6358
R556 VPWR.n128 VPWR.n1 34.6358
R557 VPWR.n129 VPWR.n128 34.6358
R558 VPWR.n107 VPWR.n6 31.624
R559 VPWR.n101 VPWR.n100 31.624
R560 VPWR.n54 VPWR.n53 31.624
R561 VPWR.n73 VPWR.n72 31.624
R562 VPWR.n23 VPWR.n21 30.7593
R563 VPWR.n23 VPWR.n18 28.9887
R564 VPWR.n118 VPWR.n4 28.9887
R565 VPWR.n63 VPWR.n59 28.9887
R566 VPWR.n35 VPWR.n32 28.9887
R567 VPWR.n22 VPWR.t8 27.9557
R568 VPWR.n116 VPWR.t9 27.9557
R569 VPWR.n117 VPWR.t7 27.9557
R570 VPWR.n20 VPWR.t16 27.9557
R571 VPWR.n58 VPWR.t6 27.9557
R572 VPWR.n44 VPWR.t14 27.9557
R573 VPWR.n31 VPWR.t11 27.9557
R574 VPWR.n130 VPWR.t12 27.9557
R575 VPWR.n98 VPWR.n12 27.1064
R576 VPWR.n110 VPWR.n109 27.1064
R577 VPWR.n79 VPWR.n56 27.1064
R578 VPWR.n88 VPWR.n87 27.1064
R579 VPWR.n105 VPWR.n104 25.6005
R580 VPWR.n102 VPWR.n9 25.6005
R581 VPWR.n81 VPWR.n80 25.6005
R582 VPWR.n70 VPWR.n38 25.6005
R583 VPWR.n104 VPWR.n12 18.824
R584 VPWR.n109 VPWR.n9 18.824
R585 VPWR.n80 VPWR.n79 18.824
R586 VPWR.n87 VPWR.n38 18.824
R587 VPWR.n98 VPWR.n96 17.3181
R588 VPWR.n112 VPWR.n110 17.3181
R589 VPWR.n65 VPWR.n56 17.3181
R590 VPWR.n89 VPWR.n88 17.3181
R591 VPWR.n107 VPWR.n105 12.8005
R592 VPWR.n102 VPWR.n101 12.8005
R593 VPWR.n81 VPWR.n54 12.8005
R594 VPWR.n72 VPWR.n70 12.8005
R595 VPWR.n122 VPWR.n121 9.78874
R596 VPWR.n26 VPWR.n25 9.78874
R597 VPWR.n45 VPWR.n43 9.78874
R598 VPWR.n131 VPWR.n129 9.78874
R599 VPWR.n47 VPWR.n43 9.3005
R600 VPWR.n49 VPWR.n48 9.3005
R601 VPWR.n51 VPWR.n50 9.3005
R602 VPWR.n53 VPWR.n52 9.3005
R603 VPWR.n54 VPWR.n40 9.3005
R604 VPWR.n82 VPWR.n81 9.3005
R605 VPWR.n80 VPWR.n41 9.3005
R606 VPWR.n79 VPWR.n78 9.3005
R607 VPWR.n67 VPWR.n56 9.3005
R608 VPWR.n66 VPWR.n65 9.3005
R609 VPWR.n64 VPWR.n57 9.3005
R610 VPWR.n63 VPWR.n62 9.3005
R611 VPWR.n25 VPWR.n24 9.3005
R612 VPWR.n26 VPWR.n19 9.3005
R613 VPWR.n94 VPWR.n27 9.3005
R614 VPWR.n17 VPWR.n16 9.3005
R615 VPWR.n100 VPWR.n99 9.3005
R616 VPWR.n101 VPWR.n14 9.3005
R617 VPWR.n103 VPWR.n102 9.3005
R618 VPWR.n10 VPWR.n9 9.3005
R619 VPWR.n109 VPWR.n108 9.3005
R620 VPWR.n110 VPWR.n7 9.3005
R621 VPWR.n113 VPWR.n112 9.3005
R622 VPWR.n111 VPWR.n3 9.3005
R623 VPWR.n123 VPWR.n4 9.3005
R624 VPWR.n121 VPWR.n5 9.3005
R625 VPWR.n123 VPWR.n122 9.3005
R626 VPWR.n115 VPWR.n3 9.3005
R627 VPWR.n114 VPWR.n113 9.3005
R628 VPWR.n7 VPWR.n6 9.3005
R629 VPWR.n108 VPWR.n107 9.3005
R630 VPWR.n105 VPWR.n10 9.3005
R631 VPWR.n104 VPWR.n103 9.3005
R632 VPWR.n14 VPWR.n12 9.3005
R633 VPWR.n99 VPWR.n98 9.3005
R634 VPWR.n96 VPWR.n17 9.3005
R635 VPWR.n95 VPWR.n94 9.3005
R636 VPWR.n19 VPWR.n18 9.3005
R637 VPWR.n24 VPWR.n23 9.3005
R638 VPWR.n129 VPWR.n0 9.3005
R639 VPWR.n128 VPWR.n127 9.3005
R640 VPWR.n2 VPWR.n1 9.3005
R641 VPWR.n74 VPWR.n73 9.3005
R642 VPWR.n72 VPWR.n68 9.3005
R643 VPWR.n70 VPWR.n69 9.3005
R644 VPWR.n39 VPWR.n38 9.3005
R645 VPWR.n87 VPWR.n86 9.3005
R646 VPWR.n88 VPWR.n30 9.3005
R647 VPWR.n90 VPWR.n89 9.3005
R648 VPWR.n36 VPWR.n29 9.3005
R649 VPWR.n35 VPWR.n34 9.3005
R650 VPWR.n92 VPWR.n91 8.71767
R651 VPWR.n76 VPWR.n75 8.71767
R652 VPWR.n85 VPWR.n84 8.71767
R653 VPWR.n126 VPWR.n125 8.71767
R654 VPWR.n84 VPWR.n83 8.71506
R655 VPWR.n92 VPWR.n28 8.71506
R656 VPWR.n77 VPWR.n76 8.71506
R657 VPWR.n60 VPWR 7.98003
R658 VPWR.n93 VPWR.n92 7.91214
R659 VPWR.n76 VPWR.n11 7.91214
R660 VPWR.n125 VPWR.n124 7.91214
R661 VPWR.n84 VPWR.n13 7.91214
R662 VPWR.n46 VPWR.n45 7.65944
R663 VPWR.n132 VPWR.n131 7.65909
R664 VPWR.n119 VPWR.n118 7.13137
R665 VPWR.n33 VPWR.n32 7.12606
R666 VPWR.n61 VPWR.n59 7.12107
R667 VPWR.n46 VPWR 2.06266
R668 VPWR.n125 VPWR 0.736833
R669 VPWR VPWR.n132 0.159538
R670 VPWR.n62 VPWR.n61 0.14551
R671 VPWR.n34 VPWR.n33 0.143094
R672 VPWR.n132 VPWR.n0 0.141672
R673 VPWR.n47 VPWR.n46 0.138802
R674 VPWR.n34 VPWR.n29 0.120292
R675 VPWR.n90 VPWR.n30 0.120292
R676 VPWR.n86 VPWR.n30 0.120292
R677 VPWR.n69 VPWR.n39 0.120292
R678 VPWR.n69 VPWR.n68 0.120292
R679 VPWR.n74 VPWR.n2 0.120292
R680 VPWR.n127 VPWR.n2 0.120292
R681 VPWR.n48 VPWR.n47 0.117847
R682 VPWR.n52 VPWR.n51 0.117847
R683 VPWR.n52 VPWR.n40 0.117847
R684 VPWR.n82 VPWR.n41 0.117847
R685 VPWR.n78 VPWR.n41 0.117847
R686 VPWR.n67 VPWR.n66 0.117847
R687 VPWR.n66 VPWR.n57 0.117847
R688 VPWR.n91 VPWR.n90 0.115083
R689 VPWR.n51 VPWR.n28 0.112745
R690 VPWR.n61 VPWR 0.111249
R691 VPWR.n85 VPWR.n39 0.0994583
R692 VPWR.n83 VPWR.n82 0.0974388
R693 VPWR.n75 VPWR.n74 0.0838333
R694 VPWR.n77 VPWR.n67 0.0821327
R695 VPWR.n33 VPWR 0.0748203
R696 VPWR.n126 VPWR.n0 0.0682083
R697 VPWR.n62 VPWR.n60 0.0668265
R698 VPWR.n24 VPWR.n19 0.0597784
R699 VPWR.n94 VPWR.n19 0.0597784
R700 VPWR.n99 VPWR.n17 0.0597784
R701 VPWR.n99 VPWR.n14 0.0597784
R702 VPWR.n103 VPWR.n10 0.0597784
R703 VPWR.n108 VPWR.n10 0.0597784
R704 VPWR.n113 VPWR.n7 0.0597784
R705 VPWR.n113 VPWR.n3 0.0597784
R706 VPWR.n123 VPWR.n5 0.0597784
R707 VPWR.n93 VPWR.n17 0.057201
R708 VPWR.n127 VPWR.n126 0.0525833
R709 VPWR.n60 VPWR.n57 0.0515204
R710 VPWR.n103 VPWR.n13 0.0494691
R711 VPWR.n24 VPWR 0.0481804
R712 VPWR.n120 VPWR.n119 0.0464491
R713 VPWR.n11 VPWR.n7 0.0417371
R714 VPWR.n75 VPWR.n68 0.0369583
R715 VPWR.n78 VPWR.n77 0.0362143
R716 VPWR.n124 VPWR.n123 0.0340052
R717 VPWR.n124 VPWR.n3 0.0262732
R718 VPWR.n86 VPWR.n85 0.0213333
R719 VPWR.n83 VPWR.n40 0.0209082
R720 VPWR.n108 VPWR.n11 0.0185412
R721 VPWR.n119 VPWR.n5 0.0147416
R722 VPWR VPWR.n21 0.0120979
R723 VPWR.n14 VPWR.n13 0.0108093
R724 VPWR.n120 VPWR 0.0108093
R725 VPWR.n91 VPWR.n29 0.00570833
R726 VPWR.n48 VPWR.n28 0.00560204
R727 VPWR.n94 VPWR.n93 0.00307732
R728 CIN.n3 CIN.t0 373.283
R729 CIN.n2 CIN.n0 357.442
R730 CIN.n1 CIN.t1 346.022
R731 CIN.n0 CIN.t5 325.082
R732 CIN.n0 CIN.t2 215.829
R733 CIN.n1 CIN.t4 193.337
R734 CIN.n3 CIN.t3 167.63
R735 CIN.n2 CIN.n1 152
R736 CIN.n4 CIN.n3 152
R737 CIN.n4 CIN.n2 88.4259
R738 CIN CIN.n4 5.3765
R739 B0.n9 B0.t3 384.529
R740 B0.n0 B0.t0 373.283
R741 B0.n4 B0.t2 351.861
R742 B0.n3 B0.t6 297.233
R743 B0.n5 B0.n4 214.362
R744 B0.n0 B0.t4 167.63
R745 B0.n10 B0.n9 157.921
R746 B0.n1 B0.n0 156.571
R747 B0.n9 B0.t7 156.382
R748 B0.n6 B0.n5 152
R749 B0.n4 B0.t1 109.215
R750 B0.n3 B0.t5 102.659
R751 B0.n5 B0.n3 47.4474
R752 B0.n7 B0.n6 10.2702
R753 B0.n6 B0 9.69747
R754 B0 B0.n1 9.37931
R755 B0.n11 B0.n10 9.3005
R756 B0.n10 B0 2.7205
R757 B0.n1 B0 2.59098
R758 B0.n2 B0 1.92014
R759 B0.n2 B0 1.79514
R760 B0.n8 B0 1.40229
R761 B0.n8 B0 0.259429
R762 B0.n7 B0.n2 0.0793043
R763 B0 B0.n7 0.0793043
R764 B0.n11 B0.n8 0.0793043
R765 B0 B0.n11 0.0793043
R766 A0.n3 A0.t5 373.283
R767 A0.n0 A0.t4 347.577
R768 A0.n11 A0.t7 334.723
R769 A0.n7 A0.t6 323.476
R770 A0.n7 A0.t2 217.436
R771 A0.n11 A0.t3 206.19
R772 A0.n0 A0.t0 193.337
R773 A0.n3 A0.t1 167.63
R774 A0.n12 A0.n11 152
R775 A0.n8 A0.n7 152
R776 A0.n4 A0.n3 152
R777 A0.n1 A0.n0 152
R778 A0.n9 A0.n8 17.8338
R779 A0.n1 A0 14.6672
R780 A0.n5 A0.n4 14.4205
R781 A0 A0.n1 13.3793
R782 A0.n13 A0.n12 10.4641
R783 A0.n8 A0 3.29747
R784 A0.n2 A0 3.15229
R785 A0.n4 A0 2.90183
R786 A0.n12 A0 2.13383
R787 A0.n6 A0 1.49157
R788 A0.n6 A0 1.40229
R789 A0.n2 A0 1.38443
R790 A0.n10 A0 0.973714
R791 A0.n10 A0 0.259429
R792 A0.n5 A0.n2 0.0793043
R793 A0 A0.n5 0.0793043
R794 A0.n9 A0.n6 0.0793043
R795 A0 A0.n9 0.0793043
R796 A0.n13 A0.n10 0.0793043
R797 A0 A0.n13 0.0793043
C0 x3.VPB B2 0.37433f
C1 a_491_n1569# x4.VPB 0.10634f
C2 A2 VGND 0.251f
C3 a_114_247# A0 0.75374f
C4 a_545_n179# VGND 0.15696f
C5 a_908_n179# VGND 0.15061f
C6 a_1033_n1185# S2 0.15151f
C7 B3 VGND 0.77592f
C8 VPWR x3.VPB 0.45824f
C9 a_545_n1459# VGND 0.20953f
C10 VPWR a_1033_95# 0.24144f
C11 VPWR B2 0.37115f
C12 a_776_n1185# VGND 0.15768f
C13 a_491_n1569# VGND 0.69936f
C14 a_1033_n1185# VGND 0.21546f
C15 x3.CIN x3.VPB 0.29283f
C16 a_152_n1851# VGND 0.32351f
C17 x3.CIN B2 0.65958f
C18 VPWR CIN 0.37395f
C19 S3 a_152_n1851# 0.15123f
C20 x3.VPB B1 0.37421f
C21 VGND a_420_n1185# 0.15726f
C22 a_776_95# VGND 0.15556f
C23 A3 B3 0.96275f
C24 VPWR x4.VPB 0.19456f
C25 VPWR x3.CIN 0.57742f
C26 VPWR a_152_n571# 0.23188f
C27 a_491_n289# x3.VPB 0.11528f
C28 a_114_n1033# A2 0.75377f
C29 VGND a_1033_95# 0.21344f
C30 B2 VGND 0.14154f
C31 x3.VPB A1 0.2969f
C32 a_491_n1569# A3 0.75421f
C33 VPWR B1 0.34692f
C34 VPWR S2 0.10043f
C35 VPWR a_776_n819# 0.15571f
C36 CIN x1.VPB 0.26325f
C37 VPWR a_420_n819# 0.16137f
C38 A3 a_152_n1851# 0.16271f
C39 CIN VGND 0.2853f
C40 VPWR x1.VPB 0.18819f
C41 CIN B0 0.78237f
C42 x3.CIN B1 0.11872f
C43 VPWR a_776_461# 0.15441f
C44 VPWR a_545_n1825# 0.15576f
C45 VPWR VGND 9.8819f
C46 VPWR B0 0.3543f
C47 VPWR a_491_n289# 0.23885f
C48 VPWR A1 0.1097f
C49 x4.VPB VGND 0.26983f
C50 x3.CIN VGND 0.25142f
C51 x3.CIN a_491_n289# 0.17789f
C52 VGND a_152_n571# 0.23823f
C53 CIN a_114_247# 0.25639f
C54 x3.VPB x2.CIN 0.27099f
C55 A1 a_152_n571# 0.16271f
C56 a_420_95# VGND 0.15227f
C57 VPWR a_114_247# 0.22779f
C58 a_491_n289# B1 0.17192f
C59 B1 A1 0.96812f
C60 x3.VPB a_114_n1033# 0.11528f
C61 VPWR A3 0.11196f
C62 x1.VPB B0 0.34842f
C63 a_1033_n1185# A2 0.16271f
C64 a_114_n1033# B2 0.17214f
C65 S3 VGND 0.11422f
C66 a_491_n289# VGND 0.45014f
C67 A1 VGND 0.18751f
C68 A0 a_1033_95# 0.16271f
C69 x4.VPB A3 0.27927f
C70 VPWR x2.CIN 0.32215f
C71 a_491_n289# A1 0.7545f
C72 a_491_n1569# B3 0.17183f
C73 VPWR a_908_n545# 0.15817f
C74 CIN A0 0.49604f
C75 VPWR a_545_n545# 0.15534f
C76 VPWR a_114_n1033# 0.23207f
C77 a_114_247# x1.VPB 0.10634f
C78 VPWR A0 0.1032f
C79 S0 a_1033_95# 0.15166f
C80 a_114_247# VGND 0.47117f
C81 x3.VPB A2 0.2969f
C82 a_114_247# B0 0.1697f
C83 x3.CIN a_114_n1033# 0.22278f
C84 B1 x2.CIN 0.69417f
C85 A2 B2 0.97549f
C86 A3 VGND 0.67794f
C87 x2.CIN VGND 0.61423f
C88 a_491_n1569# COUT 0.14507f
C89 a_491_n289# x2.CIN 0.23269f
C90 VPWR A2 0.10924f
C91 x2.CIN A1 0.49961f
C92 x1.VPB A0 0.27939f
C93 a_114_n1033# VGND 0.666f
C94 S1 a_152_n571# 0.15124f
C95 a_908_n1459# VGND 0.18755f
C96 VGND A0 0.17863f
C97 x3.CIN A2 0.4626f
C98 VPWR B3 0.35305f
C99 B0 A0 0.96522f
C100 a_420_461# CIN 0.10163f
C101 VPWR a_908_n1825# 0.15958f
C102 VPWR a_420_461# 0.16012f
C103 x2.CIN a_114_247# 0.1695f
C104 x4.VPB B3 0.34847f
C105 VPWR a_491_n1569# 0.24144f
C106 VPWR a_1033_n1185# 0.24323f
C107 S1 VGND 0.10275f
C108 VPWR a_152_n1851# 0.23387f
C109 COUT x4.VNB 0.355f
C110 S3 x4.VNB 0.33456f
C111 B3 x4.VNB 0.6891f
C112 A3 x4.VNB 0.47166f
C113 S2 x4.VNB 0.35421f
C114 B2 x4.VNB 0.86995f
C115 A2 x4.VNB 0.76565f
C116 S1 x4.VNB 0.32624f
C117 B1 x4.VNB 0.6702f
C118 A1 x4.VNB 0.45975f
C119 S0 x4.VNB 0.35402f
C120 VGND x4.VNB 1.43847f
C121 VPWR x4.VNB 2.38426f
C122 CIN x4.VNB 1.47269f
C123 B0 x4.VNB 0.86601f
C124 A0 x4.VNB 0.76922f
C125 a_491_n1569# x4.VNB 0.20634f
C126 a_114_n1033# x4.VNB 0.19521f
C127 x3.CIN x4.VNB 0.40965f
C128 a_491_n289# x4.VNB 0.1956f
C129 x2.CIN x4.VNB 0.42765f
C130 a_114_247# x4.VNB 0.20573f
C131 x4.VPB x4.VNB 1.49072f
C132 x3.VPB x4.VNB 3.07433f
C133 x1.VPB x4.VNB 1.49072f
C134 A0.t4 x4.VNB 0.10355f
C135 A0.n0 x4.VNB 0.20199f
C136 A0.n2 x4.VNB 0.40823f
C137 A0.t5 x4.VNB 0.11003f
C138 A0.n3 x4.VNB 0.20169f
C139 A0.n6 x4.VNB 0.26699f
C140 A0.n7 x4.VNB 0.20217f
C141 A0.n10 x4.VNB 0.12421f
C142 A0.t7 x4.VNB 0.10032f
C143 A0.n11 x4.VNB 0.20209f
C144 B0.t0 x4.VNB 0.10411f
C145 B0.n0 x4.VNB 0.19287f
C146 B0.n1 x4.VNB 0.11932f
C147 B0.n2 x4.VNB 0.31943f
C148 B0.n3 x4.VNB 0.17972f
C149 B0.t2 x4.VNB 0.10629f
C150 B0.n4 x4.VNB 0.18947f
C151 B0.n5 x4.VNB 0.14569f
C152 B0.n8 x4.VNB 0.15239f
C153 B0.t3 x4.VNB 0.10679f
C154 B0.n9 x4.VNB 0.19467f
C155 B0.n10 x4.VNB 0.15889f
C156 CIN.n0 x4.VNB 0.35265f
C157 CIN.n1 x4.VNB 0.16722f
C158 CIN.n2 x4.VNB 0.61461f
C159 CIN.n3 x4.VNB 0.16686f
C160 CIN.n4 x4.VNB 0.13038f
C161 VPWR.n3 x4.VNB 0.12321f
C162 VPWR.n5 x4.VNB 0.17176f
C163 VPWR.n7 x4.VNB 0.14562f
C164 VPWR.n10 x4.VNB 0.17176f
C165 VPWR.n11 x4.VNB 0.10984f
C166 VPWR.n13 x4.VNB 0.10984f
C167 VPWR.n14 x4.VNB 0.10081f
C168 VPWR.n17 x4.VNB 0.16802f
C169 VPWR.n19 x4.VNB 0.17176f
C170 VPWR.n21 x4.VNB 0.14342f
C171 VPWR.n24 x4.VNB 0.15495f
C172 VPWR.n28 x4.VNB 0.11271f
C173 VPWR.n46 x4.VNB 0.80675f
C174 VPWR.n75 x4.VNB 0.11196f
C175 VPWR.n76 x4.VNB 1.77913f
C176 VPWR.n77 x4.VNB 0.11271f
C177 VPWR.n83 x4.VNB 0.11271f
C178 VPWR.n84 x4.VNB 1.77913f
C179 VPWR.n85 x4.VNB 0.11196f
C180 VPWR.n91 x4.VNB 0.11196f
C181 VPWR.n92 x4.VNB 1.77913f
C182 VPWR.n93 x4.VNB 0.10984f
C183 VPWR.n99 x4.VNB 0.17176f
C184 VPWR.n103 x4.VNB 0.15682f
C185 VPWR.n108 x4.VNB 0.11201f
C186 VPWR.n113 x4.VNB 0.17176f
C187 VPWR.n120 x4.VNB 0.14155f
C188 VPWR.n123 x4.VNB 0.13442f
C189 VPWR.n124 x4.VNB 0.10984f
C190 VPWR.n125 x4.VNB 1.29678f
C191 VPWR.n126 x4.VNB 0.11196f
C192 VPWR.n132 x4.VNB 0.10506f
C193 VGND.n3 x4.VNB 0.17646f
C194 VGND.n4 x4.VNB 0.17466f
C195 VGND.n7 x4.VNB 0.14394f
C196 VGND.n13 x4.VNB 0.17466f
C197 VGND.n18 x4.VNB 0.15216f
C198 VGND.n20 x4.VNB 0.26519f
C199 VGND.n24 x4.VNB 0.16495f
C200 VGND.n30 x4.VNB 0.17646f
C201 VGND.n32 x4.VNB 0.11124f
C202 VGND.n35 x4.VNB 0.15344f
C203 VGND.n38 x4.VNB 0.12275f
C204 VGND.n40 x4.VNB 0.17646f
C205 VGND.n43 x4.VNB 0.15919f
C206 VGND.n44 x4.VNB 0.15075f
C207 VGND.n49 x4.VNB 0.17646f
C208 VGND.n53 x4.VNB 0.14048f
C209 VGND.n56 x4.VNB 0.17466f
C210 VGND.n58 x4.VNB 0.17466f
C211 VGND.n59 x4.VNB 0.15757f
C212 VGND.n64 x4.VNB 1.48572f
C213 VGND.n69 x4.VNB 0.17466f
C214 VGND.n79 x4.VNB 0.11011f
C215 VGND.n80 x4.VNB 1.04731f
C216 VGND.n81 x4.VNB 1.04641f
C217 VGND.n82 x4.VNB 0.15188f
C218 VGND.n86 x4.VNB 0.1215f
C219 VGND.n87 x4.VNB 1.04641f
C220 VGND.n88 x4.VNB 1.04731f
C221 VGND.n89 x4.VNB 0.14193f
C222 VGND.n95 x4.VNB 0.17646f
C223 VGND.n100 x4.VNB 0.17646f
C224 VGND.n108 x4.VNB 0.2215f
C225 VGND.n109 x4.VNB 1.51878f
C226 VGND.n110 x4.VNB 0.69131f
C227 VGND.n111 x4.VNB 0.16327f
C228 VGND.n116 x4.VNB 0.17466f
C229 VGND.n121 x4.VNB 0.19902f
C230 VGND.n122 x4.VNB 1.50171f
C231 VGND.n123 x4.VNB 0.29024f
C232 VGND.n125 x4.VNB 0.145f
C233 A1.t3 x4.VNB 0.10391f
C234 A1.n0 x4.VNB 0.20481f
C235 A1.n1 x4.VNB 0.1022f
C236 A1.n3 x4.VNB 0.16008f
C237 A1.t2 x4.VNB 0.11041f
C238 A1.n4 x4.VNB 0.20455f
C239 A1.n5 x4.VNB 0.11234f
C240 A1.n7 x4.VNB 0.30335f
C241 A1.n8 x4.VNB 0.20663f
C242 A1.n9 x4.VNB 0.12242f
C243 A1.n11 x4.VNB 0.40965f
C244 A1.t0 x4.VNB 0.10067f
C245 A1.n12 x4.VNB 0.2047f
C246 A1.n14 x4.VNB 0.15752f
C247 B1.t7 x4.VNB 0.10339f
C248 B1.n0 x4.VNB 0.18952f
C249 B1.n3 x4.VNB 0.18308f
C250 B1.t5 x4.VNB 0.10556f
C251 B1.n4 x4.VNB 0.18817f
C252 B1.n5 x4.VNB 0.17843f
C253 B1.n6 x4.VNB 0.14469f
C254 B1.n9 x4.VNB 0.31724f
C255 B1.t4 x4.VNB 0.10606f
C256 B1.n10 x4.VNB 0.19318f
C257 B1.n11 x4.VNB 0.15641f
C258 B1.n12 x4.VNB 0.18884f
C259 A2.t4 x4.VNB 0.10339f
C260 A2.n0 x4.VNB 0.20167f
C261 A2.n2 x4.VNB 0.40759f
C262 A2.t5 x4.VNB 0.10986f
C263 A2.n3 x4.VNB 0.20138f
C264 A2.n6 x4.VNB 0.26657f
C265 A2.n7 x4.VNB 0.20185f
C266 A2.n10 x4.VNB 0.12402f
C267 A2.t7 x4.VNB 0.10016f
C268 A2.n11 x4.VNB 0.20178f
C269 B2.t0 x4.VNB 0.10064f
C270 B2.n0 x4.VNB 0.18645f
C271 B2.n1 x4.VNB 0.11535f
C272 B2.n2 x4.VNB 0.3088f
C273 B2.n3 x4.VNB 0.17374f
C274 B2.t2 x4.VNB 0.10275f
C275 B2.n4 x4.VNB 0.18317f
C276 B2.n5 x4.VNB 0.14084f
C277 B2.n8 x4.VNB 0.14732f
C278 B2.t3 x4.VNB 0.10324f
C279 B2.n9 x4.VNB 0.18819f
C280 B2.n10 x4.VNB 0.1536f
C281 A3.t3 x4.VNB 0.10268f
C282 A3.n0 x4.VNB 0.20239f
C283 A3.n1 x4.VNB 0.10099f
C284 A3.n3 x4.VNB 0.15819f
C285 A3.t2 x4.VNB 0.10911f
C286 A3.n4 x4.VNB 0.20213f
C287 A3.n5 x4.VNB 0.11102f
C288 A3.n7 x4.VNB 0.29977f
C289 A3.n8 x4.VNB 0.20419f
C290 A3.n9 x4.VNB 0.12098f
C291 A3.n11 x4.VNB 0.40481f
C292 A3.n12 x4.VNB 0.20228f
C293 A3.n14 x4.VNB 0.15191f
C294 B3.t7 x4.VNB 0.10048f
C295 B3.n0 x4.VNB 0.18419f
C296 B3.n3 x4.VNB 0.17793f
C297 B3.t5 x4.VNB 0.10259f
C298 B3.n4 x4.VNB 0.18288f
C299 B3.n5 x4.VNB 0.17341f
C300 B3.n6 x4.VNB 0.14062f
C301 B3.n9 x4.VNB 0.30831f
C302 B3.t4 x4.VNB 0.10308f
C303 B3.n10 x4.VNB 0.18775f
C304 B3.n11 x4.VNB 0.15201f
C305 B3.n12 x4.VNB 0.17692f
.ends
