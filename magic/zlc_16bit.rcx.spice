* NGSPICE file created from zlc_16bit.ext - technology: sky130A

.subckt zlc_16bit Y[2] Y[0] A[15] A[12] A[13] A[14] VDD GND Y[3] Y[1] A[2] A[1] A[0]
+ A[3] A[11] A[8] A[9] A[10] A[6] A[5] A[4] A[7] Y[4]
X0 Z1[2] A[4].t3 GND.t205 GND.t204 sky130_fd_pr__nfet_01v8 ad=0.11863 pd=1.015 as=0.169 ps=1.82 w=0.65 l=0.15
X1 GND.t132 x3.x9.B a_3367_n2437# GND.t131 sky130_fd_pr__nfet_01v8 ad=0.1118 pd=1.04 as=0.0567 ps=0.69 w=0.42 l=0.15
X2 Z2[2] A[10].t3 GND.t247 GND.t246 sky130_fd_pr__nfet_01v8 ad=0.08775 pd=0.92 as=0.08937 ps=0.925 w=0.65 l=0.15
X3 a_285_n935# A[9].t5 a_203_n935# VDD.t171 sky130_fd_pr__pfet_01v8_hvt ad=0.19 pd=1.38 as=0.13 ps=1.26 w=1 l=0.15
X4 a_203_n2215# A[4].t5 Z1[2] VDD.t212 sky130_fd_pr__pfet_01v8_hvt ad=0.13 pd=1.26 as=0.26 ps=2.52 w=1 l=0.15
X5 GND.t215 A[5].t3 Z1[2] GND.t214 sky130_fd_pr__nfet_01v8 ad=0.08937 pd=0.925 as=0.11863 ps=1.015 w=0.65 l=0.15
X6 VDD.t92 x2.x8.A a_2912_n935# VDD.t91 sky130_fd_pr__pfet_01v8_hvt ad=0.14575 pd=1.335 as=0.0441 ps=0.63 w=0.42 l=0.15
X7 GND.t195 Y[3].t5 a_1819_n3066# GND.t194 sky130_fd_pr__nfet_01v8 ad=0.1449 pd=1.11 as=0.1092 ps=1.36 w=0.42 l=0.15
X8 a_1245_n2739# a_991_n3066# GND.t135 GND.t134 sky130_fd_pr__nfet_01v8 ad=0.0693 pd=0.75 as=0.1449 ps=1.11 w=0.42 l=0.15
X9 GND.t30 x1.x8.A a_2830_345# GND.t29 sky130_fd_pr__nfet_01v8 ad=0.10025 pd=0.985 as=0.0567 ps=0.69 w=0.42 l=0.15
X10 a_1173_n3066# a_991_n3066# VDD.t150 VDD.t149 sky130_fd_pr__pfet_01v8_hvt ad=0.0441 pd=0.63 as=0.0693 ps=0.75 w=0.42 l=0.15
X11 x3.x9.B a_2830_n2215# GND.t146 GND.t145 sky130_fd_pr__nfet_01v8 ad=0.169 pd=1.82 as=0.10025 ps=0.985 w=0.65 l=0.15
X12 GND.t123 a_1193_n313# x11.B GND.t122 sky130_fd_pr__nfet_01v8 ad=0.1118 pd=1.04 as=0.182 ps=1.86 w=0.65 l=0.15
X13 x9.Y Z0[2] GND.t59 GND.t58 sky130_fd_pr__nfet_01v8 ad=0.169 pd=1.82 as=0.169 ps=1.82 w=0.65 l=0.15
X14 x16.A0 a_3281_123# GND.t26 GND.t25 sky130_fd_pr__nfet_01v8 ad=0.182 pd=1.86 as=0.1118 ps=1.04 w=0.65 l=0.15
X15 a_3367_n2437# x3.x9.A a_3281_n2437# GND.t10 sky130_fd_pr__nfet_01v8 ad=0.0567 pd=0.69 as=0.1176 ps=1.4 w=0.42 l=0.15
X16 x3.x9.B a_2830_n2215# VDD.t161 VDD.t160 sky130_fd_pr__pfet_01v8_hvt ad=0.34 pd=2.68 as=0.14575 ps=1.335 w=1 l=0.15
X17 a_391_345# A[14].t5 a_285_345# VDD.t209 sky130_fd_pr__pfet_01v8_hvt ad=0.135 pd=1.27 as=0.19 ps=1.38 w=1 l=0.15
X18 a_2073_n2739# a_1819_n3066# GND.t187 GND.t186 sky130_fd_pr__nfet_01v8 ad=0.0693 pd=0.75 as=0.1449 ps=1.11 w=0.42 l=0.15
X19 a_1466_n2739# Z0[0] a_1245_n3066# GND.t133 sky130_fd_pr__nfet_01v8 ad=0.0693 pd=0.75 as=0.09975 ps=0.895 w=0.42 l=0.15
X20 GND.t241 A[15].t3 Z3[2] GND.t240 sky130_fd_pr__nfet_01v8 ad=0.169 pd=1.82 as=0.08775 ps=0.92 w=0.65 l=0.15
X21 GND.t211 A[11].t2 x2.x4.A GND.t210 sky130_fd_pr__nfet_01v8 ad=0.169 pd=1.82 as=0.08775 ps=0.92 w=0.65 l=0.15
X22 x2.x7.A A[9].t0 GND.t161 GND.t160 sky130_fd_pr__nfet_01v8 ad=0.169 pd=1.82 as=0.169 ps=1.82 w=0.65 l=0.15
X23 a_1349_123# x1.x4.A VDD.t23 VDD.t22 sky130_fd_pr__pfet_01v8_hvt ad=0.0567 pd=0.69 as=0.1176 ps=1.4 w=0.42 l=0.15
X24 GND.t139 A[13].t3 Z3[2] GND.t138 sky130_fd_pr__nfet_01v8 ad=0.08937 pd=0.925 as=0.11863 ps=1.015 w=0.65 l=0.15
X25 GND.t253 A[0].t0 a_2447_n3717# GND.t252 sky130_fd_pr__nfet_01v8 ad=0.1118 pd=1.04 as=0.0567 ps=0.69 w=0.42 l=0.15
X26 x4.x9.A A[3].t1 VDD.t235 VDD.t234 sky130_fd_pr__pfet_01v8_hvt ad=0.26 pd=2.52 as=0.26 ps=2.52 w=1 l=0.15
X27 VDD.t208 Y[3].t3 a_1819_n3066# VDD.t207 sky130_fd_pr__pfet_01v8_hvt ad=0.0693 pd=0.75 as=0.1176 ps=1.4 w=0.42 l=0.15
X28 a_1245_n3066# Z0[0] a_1173_n3066# VDD.t148 sky130_fd_pr__pfet_01v8_hvt ad=0.1932 pd=1.34 as=0.0441 ps=0.63 w=0.42 l=0.15
X29 a_2912_345# A[14].t1 a_2830_345# VDD.t211 sky130_fd_pr__pfet_01v8_hvt ad=0.0441 pd=0.63 as=0.1092 ps=1.36 w=0.42 l=0.15
X30 GND.t42 x1.x9.B a_3367_123# GND.t41 sky130_fd_pr__nfet_01v8 ad=0.1118 pd=1.04 as=0.0567 ps=0.69 w=0.42 l=0.15
X31 a_417_n1459# a_163_n1786# GND.t92 GND.t91 sky130_fd_pr__nfet_01v8 ad=0.0693 pd=0.75 as=0.1449 ps=1.11 w=0.42 l=0.15
X32 a_417_n1786# x13.A1 a_345_n1786# VDD.t81 sky130_fd_pr__pfet_01v8_hvt ad=0.1932 pd=1.34 as=0.0441 ps=0.63 w=0.42 l=0.15
X33 a_345_n3066# a_163_n3066# VDD.t163 VDD.t162 sky130_fd_pr__pfet_01v8_hvt ad=0.0441 pd=0.63 as=0.0693 ps=0.75 w=0.42 l=0.15
X34 x1.x9.A A[15].t0 GND.t243 GND.t242 sky130_fd_pr__nfet_01v8 ad=0.169 pd=1.82 as=0.169 ps=1.82 w=0.65 l=0.15
X35 a_2294_n2739# x17.X a_2073_n3066# GND.t151 sky130_fd_pr__nfet_01v8 ad=0.0693 pd=0.75 as=0.09975 ps=0.895 w=0.42 l=0.15
X36 a_898_n935# A[8].t2 GND.t165 GND.t164 sky130_fd_pr__nfet_01v8 ad=0.0567 pd=0.69 as=0.1092 ps=1.36 w=0.42 l=0.15
X37 VDD.t141 x4.x9.B a_3281_n3717# VDD.t140 sky130_fd_pr__pfet_01v8_hvt ad=0.16655 pd=1.39 as=0.0567 ps=0.69 w=0.42 l=0.15
X38 a_2073_n3066# x17.X a_2001_n3066# VDD.t166 sky130_fd_pr__pfet_01v8_hvt ad=0.1932 pd=1.34 as=0.0441 ps=0.63 w=0.42 l=0.15
X39 a_638_n2739# x16.A1 a_417_n3066# GND.t75 sky130_fd_pr__nfet_01v8 ad=0.0693 pd=0.75 as=0.09975 ps=0.895 w=0.42 l=0.15
X40 VDD.t244 A[15].t4 a_663_345# VDD.t243 sky130_fd_pr__pfet_01v8_hvt ad=0.26 pd=2.52 as=0.105 ps=1.21 w=1 l=0.15
X41 a_447_n207# x10.B GND.t125 GND.t124 sky130_fd_pr__nfet_01v8 ad=0.0567 pd=0.69 as=0.1118 ps=1.04 w=0.42 l=0.15
X42 x13.A1 a_1349_n1157# VDD.t157 VDD.t156 sky130_fd_pr__pfet_01v8_hvt ad=0.475 pd=2.95 as=0.16655 ps=1.39 w=1 l=0.15
X43 a_2447_n3717# x4.x7.A a_2361_n3717# GND.t169 sky130_fd_pr__nfet_01v8 ad=0.0567 pd=0.69 as=0.1176 ps=1.4 w=0.42 l=0.15
X44 a_914_n429# x8.Y VDD.t44 VDD.t43 sky130_fd_pr__pfet_01v8_hvt ad=0.0441 pd=0.63 as=0.14575 ps=1.335 w=0.42 l=0.15
X45 a_1245_n3066# Z1[0] a_1245_n2739# GND.t11 sky130_fd_pr__nfet_01v8 ad=0.09975 pd=0.895 as=0.0693 ps=0.75 w=0.42 l=0.15
X46 x1.x9.B a_2830_345# GND.t28 GND.t27 sky130_fd_pr__nfet_01v8 ad=0.169 pd=1.82 as=0.10025 ps=0.985 w=0.65 l=0.15
X47 VDD.t25 Z3[2] a_2933_n571# VDD.t24 sky130_fd_pr__pfet_01v8_hvt ad=0.1092 pd=1.36 as=0.0735 ps=0.77 w=0.42 l=0.15
X48 a_2830_n2215# A[6].t0 GND.t225 GND.t224 sky130_fd_pr__nfet_01v8 ad=0.0567 pd=0.69 as=0.1092 ps=1.36 w=0.42 l=0.15
X49 a_663_n935# A[10].t4 x2.x4.A VDD.t248 sky130_fd_pr__pfet_01v8_hvt ad=0.105 pd=1.21 as=0.26 ps=2.52 w=1 l=0.15
X50 a_3281_n3717# x4.x9.A VDD.t119 VDD.t118 sky130_fd_pr__pfet_01v8_hvt ad=0.0567 pd=0.69 as=0.1176 ps=1.4 w=0.42 l=0.15
X51 a_3225_n179# Z1[2] a_3129_n179# GND.t49 sky130_fd_pr__nfet_01v8 ad=0.0798 pd=0.8 as=0.0693 ps=0.75 w=0.42 l=0.15
X52 GND.t235 A[1].t2 a_898_n3495# GND.t234 sky130_fd_pr__nfet_01v8 ad=0.10025 pd=0.985 as=0.0567 ps=0.69 w=0.42 l=0.15
X53 x3.x9.A A[7].t0 GND.t257 GND.t256 sky130_fd_pr__nfet_01v8 ad=0.169 pd=1.82 as=0.169 ps=1.82 w=0.65 l=0.15
X54 GND.t185 Y[2].t6 a_1466_n2739# GND.t184 sky130_fd_pr__nfet_01v8 ad=0.11285 pd=1.045 as=0.0693 ps=0.75 w=0.42 l=0.15
X55 GND.t137 A[13].t2 a_898_345# GND.t136 sky130_fd_pr__nfet_01v8 ad=0.10025 pd=0.985 as=0.0567 ps=0.69 w=0.42 l=0.15
X56 VDD.t78 a_273_n313# Y[2].t0 VDD.t77 sky130_fd_pr__pfet_01v8_hvt ad=0.16655 pd=1.39 as=0.475 ps=2.95 w=1 l=0.15
X57 a_203_n935# A[8].t5 Z2[2] VDD.t176 sky130_fd_pr__pfet_01v8_hvt ad=0.13 pd=1.26 as=0.26 ps=2.52 w=1 l=0.15
X58 x4.x4.A A[2].t2 GND.t265 GND.t264 sky130_fd_pr__nfet_01v8 ad=0.08775 pd=0.92 as=0.169 ps=1.82 w=0.65 l=0.15
X59 a_2001_n3066# a_1819_n3066# VDD.t200 VDD.t199 sky130_fd_pr__pfet_01v8_hvt ad=0.0441 pd=0.63 as=0.0693 ps=0.75 w=0.42 l=0.15
X60 GND.t61 Z0[2] a_2687_n225# GND.t60 sky130_fd_pr__nfet_01v8 ad=0.169 pd=1.82 as=0.08775 ps=0.92 w=0.65 l=0.15
X61 a_2193_n313# Z3[2] VDD.t27 VDD.t26 sky130_fd_pr__pfet_01v8_hvt ad=0.1092 pd=1.36 as=0.0567 ps=0.69 w=0.42 l=0.15
X62 VDD.t83 x2.x4.B a_1349_n1157# VDD.t82 sky130_fd_pr__pfet_01v8_hvt ad=0.16655 pd=1.39 as=0.0567 ps=0.69 w=0.42 l=0.15
X63 x3.x9.A A[7].t1 VDD.t255 VDD.t254 sky130_fd_pr__pfet_01v8_hvt ad=0.26 pd=2.52 as=0.26 ps=2.52 w=1 l=0.15
X64 a_3367_123# x1.x9.A a_3281_123# GND.t32 sky130_fd_pr__nfet_01v8 ad=0.0567 pd=0.69 as=0.1176 ps=1.4 w=0.42 l=0.15
X65 a_417_n1786# x13.A0 a_417_n1459# GND.t33 sky130_fd_pr__nfet_01v8 ad=0.09975 pd=0.895 as=0.0693 ps=0.75 w=0.42 l=0.15
X66 GND.t5 x3.x4.B a_1435_n2437# GND.t4 sky130_fd_pr__nfet_01v8 ad=0.1118 pd=1.04 as=0.0567 ps=0.69 w=0.42 l=0.15
X67 GND.t191 Y[3].t4 a_2294_n2739# GND.t190 sky130_fd_pr__nfet_01v8 ad=0.11285 pd=1.045 as=0.0693 ps=0.75 w=0.42 l=0.15
X68 GND.t209 A[11].t3 Z2[2] GND.t208 sky130_fd_pr__nfet_01v8 ad=0.169 pd=1.82 as=0.08775 ps=0.92 w=0.65 l=0.15
X69 x13.A1 a_1349_n1157# GND.t143 GND.t142 sky130_fd_pr__nfet_01v8 ad=0.182 pd=1.86 as=0.1118 ps=1.04 w=0.65 l=0.15
X70 a_2912_n3495# A[2].t1 a_2830_n3495# VDD.t262 sky130_fd_pr__pfet_01v8_hvt ad=0.0441 pd=0.63 as=0.1092 ps=1.36 w=0.42 l=0.15
X71 VDD.t192 Y[2].t2 a_1459_n3066# VDD.t191 sky130_fd_pr__pfet_01v8_hvt ad=0.15835 pd=1.395 as=0.07665 ps=0.785 w=0.42 l=0.15
X72 GND.t183 Y[2].t8 a_638_n2739# GND.t182 sky130_fd_pr__nfet_01v8 ad=0.11285 pd=1.045 as=0.0693 ps=0.75 w=0.42 l=0.15
X73 x1.x9.A A[15].t1 VDD.t246 VDD.t245 sky130_fd_pr__pfet_01v8_hvt ad=0.26 pd=2.52 as=0.26 ps=2.52 w=1 l=0.15
X74 x4.x4.B a_898_n3495# GND.t155 GND.t154 sky130_fd_pr__nfet_01v8 ad=0.169 pd=1.82 as=0.10025 ps=0.985 w=0.65 l=0.15
X75 GND.t177 Y[2].t15 a_991_n1786# GND.t176 sky130_fd_pr__nfet_01v8 ad=0.1449 pd=1.11 as=0.1092 ps=1.36 w=0.42 l=0.15
X76 VDD.t184 Y[2].t11 a_991_n1786# VDD.t183 sky130_fd_pr__pfet_01v8_hvt ad=0.0693 pd=0.75 as=0.1176 ps=1.4 w=0.42 l=0.15
X77 x4.x8.A a_2361_n3717# VDD.t125 VDD.t124 sky130_fd_pr__pfet_01v8_hvt ad=0.475 pd=2.95 as=0.16655 ps=1.39 w=1 l=0.15
X78 x17.X a_1245_n3066# GND.t7 GND.t6 sky130_fd_pr__nfet_01v8 ad=0.169 pd=1.82 as=0.11285 ps=1.045 w=0.65 l=0.15
X79 VDD.t131 x4.x8.A a_2912_n3495# VDD.t130 sky130_fd_pr__pfet_01v8_hvt ad=0.14575 pd=1.335 as=0.0441 ps=0.63 w=0.42 l=0.15
X80 VDD.t206 Y[3].t2 a_2287_n3066# VDD.t205 sky130_fd_pr__pfet_01v8_hvt ad=0.15835 pd=1.395 as=0.07665 ps=0.785 w=0.42 l=0.15
X81 a_631_n3066# x16.A0 a_417_n3066# VDD.t47 sky130_fd_pr__pfet_01v8_hvt ad=0.07665 pd=0.785 as=0.1932 ps=1.34 w=0.42 l=0.15
X82 VDD.t155 A[13].t4 a_980_345# VDD.t154 sky130_fd_pr__pfet_01v8_hvt ad=0.14575 pd=1.335 as=0.0441 ps=0.63 w=0.42 l=0.15
X83 a_2427_n179# Z2[2] a_2355_n179# GND.t56 sky130_fd_pr__nfet_01v8 ad=0.0441 pd=0.63 as=0.0441 ps=0.63 w=0.42 l=0.15
X84 a_3281_n1157# x2.x9.A VDD.t87 VDD.t86 sky130_fd_pr__pfet_01v8_hvt ad=0.0567 pd=0.69 as=0.1176 ps=1.4 w=0.42 l=0.15
X85 x16.A1 a_3281_n1157# GND.t9 GND.t8 sky130_fd_pr__nfet_01v8 ad=0.182 pd=1.86 as=0.1118 ps=1.04 w=0.65 l=0.15
X86 VDD.t194 Y[2].t4 a_631_n3066# VDD.t193 sky130_fd_pr__pfet_01v8_hvt ad=0.15835 pd=1.395 as=0.07665 ps=0.785 w=0.42 l=0.15
X87 a_751_n313# x11.B a_914_n429# VDD.t50 sky130_fd_pr__pfet_01v8_hvt ad=0.1092 pd=1.36 as=0.0441 ps=0.63 w=0.42 l=0.15
X88 GND.t171 Y[2].t17 a_163_n1786# GND.t170 sky130_fd_pr__nfet_01v8 ad=0.1449 pd=1.11 as=0.1092 ps=1.36 w=0.42 l=0.15
X89 VDD.t186 Y[2].t13 a_163_n1786# VDD.t185 sky130_fd_pr__pfet_01v8_hvt ad=0.0693 pd=0.75 as=0.1176 ps=1.4 w=0.42 l=0.15
X90 a_663_345# A[14].t4 x1.x4.A VDD.t210 sky130_fd_pr__pfet_01v8_hvt ad=0.105 pd=1.21 as=0.26 ps=2.52 w=1 l=0.15
X91 VDD.t29 Z3[2] a_273_n313# VDD.t28 sky130_fd_pr__pfet_01v8_hvt ad=0.1176 pd=1.4 as=0.0567 ps=0.69 w=0.42 l=0.15
X92 x16.X a_417_n3066# GND.t103 GND.t102 sky130_fd_pr__nfet_01v8 ad=0.169 pd=1.82 as=0.11285 ps=1.045 w=0.65 l=0.15
X93 VDD.t179 A[8].t1 a_2361_n1157# VDD.t178 sky130_fd_pr__pfet_01v8_hvt ad=0.16655 pd=1.39 as=0.0567 ps=0.69 w=0.42 l=0.15
X94 VDD.t127 x4.x4.B a_1349_n3717# VDD.t126 sky130_fd_pr__pfet_01v8_hvt ad=0.16655 pd=1.39 as=0.0567 ps=0.69 w=0.42 l=0.15
X95 a_1367_n207# x9.Y GND.t65 GND.t64 sky130_fd_pr__nfet_01v8 ad=0.0567 pd=0.69 as=0.1118 ps=1.04 w=0.42 l=0.15
X96 VDD.t217 A[11].t4 a_663_n935# VDD.t216 sky130_fd_pr__pfet_01v8_hvt ad=0.26 pd=2.52 as=0.105 ps=1.21 w=1 l=0.15
X97 a_2912_n2215# A[6].t1 a_2830_n2215# VDD.t229 sky130_fd_pr__pfet_01v8_hvt ad=0.0441 pd=0.63 as=0.1092 ps=1.36 w=0.42 l=0.15
X98 Z0[2] A[2].t3 GND.t263 GND.t262 sky130_fd_pr__nfet_01v8 ad=0.08775 pd=0.92 as=0.08937 ps=0.925 w=0.65 l=0.15
X99 a_285_345# A[13].t5 a_203_345# VDD.t151 sky130_fd_pr__pfet_01v8_hvt ad=0.19 pd=1.38 as=0.13 ps=1.26 w=1 l=0.15
X100 VDD.t46 a_751_n313# x10.B VDD.t45 sky130_fd_pr__pfet_01v8_hvt ad=0.14575 pd=1.335 as=0.34 ps=2.68 w=1 l=0.15
X101 a_1173_n1786# a_991_n1786# VDD.t102 VDD.t101 sky130_fd_pr__pfet_01v8_hvt ad=0.0441 pd=0.63 as=0.0693 ps=0.75 w=0.42 l=0.15
X102 a_1435_n2437# x3.x4.A a_1349_n2437# GND.t144 sky130_fd_pr__nfet_01v8 ad=0.0567 pd=0.69 as=0.1176 ps=1.4 w=0.42 l=0.15
X103 x3.x8.A a_2361_n2437# GND.t129 GND.t128 sky130_fd_pr__nfet_01v8 ad=0.182 pd=1.86 as=0.1118 ps=1.04 w=0.65 l=0.15
X104 a_980_345# A[12].t4 a_898_345# VDD.t133 sky130_fd_pr__pfet_01v8_hvt ad=0.0441 pd=0.63 as=0.1092 ps=1.36 w=0.42 l=0.15
X105 GND.t101 x3.x8.A a_2830_n2215# GND.t100 sky130_fd_pr__nfet_01v8 ad=0.10025 pd=0.985 as=0.0567 ps=0.69 w=0.42 l=0.15
X106 GND.t77 x2.x9.B a_3367_n1157# GND.t76 sky130_fd_pr__nfet_01v8 ad=0.1118 pd=1.04 as=0.0567 ps=0.69 w=0.42 l=0.15
X107 x14.X a_1245_n1786# GND.t84 GND.t83 sky130_fd_pr__nfet_01v8 ad=0.169 pd=1.82 as=0.11285 ps=1.045 w=0.65 l=0.15
X108 x3.x8.A a_2361_n2437# VDD.t143 VDD.t142 sky130_fd_pr__pfet_01v8_hvt ad=0.475 pd=2.95 as=0.16655 ps=1.39 w=1 l=0.15
X109 Z2[2] A[8].t3 GND.t163 GND.t162 sky130_fd_pr__nfet_01v8 ad=0.11863 pd=1.015 as=0.169 ps=1.82 w=0.65 l=0.15
X110 VDD.t115 x3.x8.A a_2912_n2215# VDD.t114 sky130_fd_pr__pfet_01v8_hvt ad=0.14575 pd=1.335 as=0.0441 ps=0.63 w=0.42 l=0.15
X111 VDD.t49 x1.x9.B a_3281_123# VDD.t48 sky130_fd_pr__pfet_01v8_hvt ad=0.16655 pd=1.39 as=0.0567 ps=0.69 w=0.42 l=0.15
X112 VDD.t137 a_1193_n313# x11.B VDD.t136 sky130_fd_pr__pfet_01v8_hvt ad=0.16655 pd=1.39 as=0.475 ps=2.95 w=1 l=0.15
X113 x9.Y Z0[2] VDD.t74 VDD.t73 sky130_fd_pr__pfet_01v8_hvt ad=0.26 pd=2.52 as=0.26 ps=2.52 w=1 l=0.15
X114 GND.t157 A[9].t3 Z2[2] GND.t156 sky130_fd_pr__nfet_01v8 ad=0.08937 pd=0.925 as=0.11863 ps=1.015 w=0.65 l=0.15
X115 GND.t189 Y[3].t9 a_1819_n1786# GND.t188 sky130_fd_pr__nfet_01v8 ad=0.1449 pd=1.11 as=0.1092 ps=1.36 w=0.42 l=0.15
X116 a_1245_n1786# x4.Z[1] a_1173_n1786# VDD.t99 sky130_fd_pr__pfet_01v8_hvt ad=0.1932 pd=1.34 as=0.0441 ps=0.63 w=0.42 l=0.15
X117 VDD.t202 Y[3].t7 a_1819_n1786# VDD.t201 sky130_fd_pr__pfet_01v8_hvt ad=0.0693 pd=0.75 as=0.1176 ps=1.4 w=0.42 l=0.15
X118 x4.x7.A A[1].t0 GND.t237 GND.t236 sky130_fd_pr__nfet_01v8 ad=0.169 pd=1.82 as=0.169 ps=1.82 w=0.65 l=0.15
X119 GND.t231 A[3].t2 x4.x4.A GND.t230 sky130_fd_pr__nfet_01v8 ad=0.169 pd=1.82 as=0.08775 ps=0.92 w=0.65 l=0.15
X120 x17.X a_1245_n3066# VDD.t7 VDD.t6 sky130_fd_pr__pfet_01v8_hvt ad=0.26 pd=2.52 as=0.15835 ps=1.395 w=1 l=0.15
X121 a_3129_n179# Z0[2] GND.t63 GND.t62 sky130_fd_pr__nfet_01v8 ad=0.0693 pd=0.75 as=0.19627 ps=1.33 w=0.42 l=0.15
X122 a_1245_n1459# a_991_n1786# GND.t88 GND.t87 sky130_fd_pr__nfet_01v8 ad=0.0693 pd=0.75 as=0.1449 ps=1.11 w=0.42 l=0.15
X123 a_345_n1786# a_163_n1786# VDD.t106 VDD.t105 sky130_fd_pr__pfet_01v8_hvt ad=0.0441 pd=0.63 as=0.0693 ps=0.75 w=0.42 l=0.15
X124 a_2933_n571# Z2[2] VDD.t66 VDD.t65 sky130_fd_pr__pfet_01v8_hvt ad=0.0735 pd=0.77 as=0.0777 ps=0.79 w=0.42 l=0.15
X125 x2.x9.B a_2830_n935# GND.t1 GND.t0 sky130_fd_pr__nfet_01v8 ad=0.169 pd=1.82 as=0.10025 ps=0.985 w=0.65 l=0.15
X126 GND.t55 Z2[2] x8.Y GND.t54 sky130_fd_pr__nfet_01v8 ad=0.169 pd=1.82 as=0.169 ps=1.82 w=0.65 l=0.15
X127 a_3331_n179# Z2[2] a_3225_n179# GND.t57 sky130_fd_pr__nfet_01v8 ad=0.0609 pd=0.71 as=0.0798 ps=0.8 w=0.42 l=0.15
X128 x13.X a_417_n1786# GND.t90 GND.t89 sky130_fd_pr__nfet_01v8 ad=0.169 pd=1.82 as=0.11285 ps=1.045 w=0.65 l=0.15
X129 a_2193_n313# Z3[2] a_2427_n179# GND.t23 sky130_fd_pr__nfet_01v8 ad=0.1092 pd=1.36 as=0.0441 ps=0.63 w=0.42 l=0.15
X130 a_3367_n1157# x2.x9.A a_3281_n1157# GND.t74 sky130_fd_pr__nfet_01v8 ad=0.0567 pd=0.69 as=0.1176 ps=1.4 w=0.42 l=0.15
X131 a_2073_n1459# a_1819_n1786# GND.t82 GND.t81 sky130_fd_pr__nfet_01v8 ad=0.0693 pd=0.75 as=0.1449 ps=1.11 w=0.42 l=0.15
X132 a_2073_n1786# x14.X a_2001_n1786# VDD.t15 sky130_fd_pr__pfet_01v8_hvt ad=0.1932 pd=1.34 as=0.0441 ps=0.63 w=0.42 l=0.15
X133 a_898_n3495# A[0].t2 GND.t255 GND.t254 sky130_fd_pr__nfet_01v8 ad=0.0567 pd=0.69 as=0.1092 ps=1.36 w=0.42 l=0.15
X134 a_1466_n1459# x4.Z[1] a_1245_n1786# GND.t85 sky130_fd_pr__nfet_01v8 ad=0.0693 pd=0.75 as=0.09975 ps=0.895 w=0.42 l=0.15
X135 a_2073_n3066# x16.X a_2073_n2739# GND.t168 sky130_fd_pr__nfet_01v8 ad=0.09975 pd=0.895 as=0.0693 ps=0.75 w=0.42 l=0.15
X136 VDD.t238 A[1].t4 a_980_n3495# VDD.t237 sky130_fd_pr__pfet_01v8_hvt ad=0.14575 pd=1.335 as=0.0441 ps=0.63 w=0.42 l=0.15
X137 x16.X a_417_n3066# VDD.t117 VDD.t116 sky130_fd_pr__pfet_01v8_hvt ad=0.26 pd=2.52 as=0.15835 ps=1.395 w=1 l=0.15
X138 GND.t203 A[4].t0 a_2447_n2437# GND.t202 sky130_fd_pr__nfet_01v8 ad=0.1118 pd=1.04 as=0.0567 ps=0.69 w=0.42 l=0.15
X139 a_663_n3495# A[2].t4 x4.x4.A VDD.t261 sky130_fd_pr__pfet_01v8_hvt ad=0.105 pd=1.21 as=0.26 ps=2.52 w=1 l=0.15
X140 Z3[2] A[12].t3 GND.t119 GND.t118 sky130_fd_pr__nfet_01v8 ad=0.11863 pd=1.015 as=0.169 ps=1.82 w=0.65 l=0.15
X141 a_2294_n1459# x14.X a_2073_n1786# GND.t14 sky130_fd_pr__nfet_01v8 ad=0.0693 pd=0.75 as=0.09975 ps=0.895 w=0.42 l=0.15
X142 a_1349_n3717# x4.x4.A VDD.t129 VDD.t128 sky130_fd_pr__pfet_01v8_hvt ad=0.0567 pd=0.69 as=0.1176 ps=1.4 w=0.42 l=0.15
X143 x1.x4.A A[14].t2 GND.t197 GND.t196 sky130_fd_pr__nfet_01v8 ad=0.08775 pd=0.92 as=0.169 ps=1.82 w=0.65 l=0.15
X144 VDD.t147 x3.x9.B a_3281_n2437# VDD.t146 sky130_fd_pr__pfet_01v8_hvt ad=0.16655 pd=1.39 as=0.0567 ps=0.69 w=0.42 l=0.15
X145 a_1459_n3066# Z1[0] a_1245_n3066# VDD.t12 sky130_fd_pr__pfet_01v8_hvt ad=0.07665 pd=0.785 as=0.1932 ps=1.34 w=0.42 l=0.15
X146 x1.x4.B a_898_345# VDD.t19 VDD.t18 sky130_fd_pr__pfet_01v8_hvt ad=0.34 pd=2.68 as=0.14575 ps=1.335 w=1 l=0.15
X147 GND.t35 x1.x4.B a_1435_123# GND.t34 sky130_fd_pr__nfet_01v8 ad=0.1118 pd=1.04 as=0.0567 ps=0.69 w=0.42 l=0.15
X148 a_638_n1459# x13.A1 a_417_n1786# GND.t70 sky130_fd_pr__nfet_01v8 ad=0.0693 pd=0.75 as=0.09975 ps=0.895 w=0.42 l=0.15
X149 VDD.t233 A[3].t4 a_663_n3495# VDD.t232 sky130_fd_pr__pfet_01v8_hvt ad=0.26 pd=2.52 as=0.105 ps=1.21 w=1 l=0.15
X150 a_3281_123# x1.x9.A VDD.t39 VDD.t38 sky130_fd_pr__pfet_01v8_hvt ad=0.0567 pd=0.69 as=0.1176 ps=1.4 w=0.42 l=0.15
X151 VDD.t58 Z1[2] a_1193_n313# VDD.t57 sky130_fd_pr__pfet_01v8_hvt ad=0.1176 pd=1.4 as=0.0567 ps=0.69 w=0.42 l=0.15
X152 a_2001_n1786# a_1819_n1786# VDD.t96 VDD.t95 sky130_fd_pr__pfet_01v8_hvt ad=0.0441 pd=0.63 as=0.0693 ps=0.75 w=0.42 l=0.15
X153 x4.x4.B a_898_n3495# VDD.t170 VDD.t169 sky130_fd_pr__pfet_01v8_hvt ad=0.34 pd=2.68 as=0.14575 ps=1.335 w=1 l=0.15
X154 a_2447_n2437# x3.x7.A a_2361_n2437# GND.t130 sky130_fd_pr__nfet_01v8 ad=0.0567 pd=0.69 as=0.1176 ps=1.4 w=0.42 l=0.15
X155 GND.t46 a_2933_n571# Y[4].t1 GND.t45 sky130_fd_pr__nfet_01v8 ad=0.19627 pd=1.33 as=0.169 ps=1.82 w=0.65 l=0.15
X156 a_1245_n1786# x3.Z[1] a_1245_n1459# GND.t86 sky130_fd_pr__nfet_01v8 ad=0.09975 pd=0.895 as=0.0693 ps=0.75 w=0.42 l=0.15
X157 a_2287_n3066# x16.X a_2073_n3066# VDD.t180 sky130_fd_pr__pfet_01v8_hvt ad=0.07665 pd=0.785 as=0.1932 ps=1.34 w=0.42 l=0.15
X158 x1.x4.B a_898_345# GND.t18 GND.t17 sky130_fd_pr__nfet_01v8 ad=0.169 pd=1.82 as=0.10025 ps=0.985 w=0.65 l=0.15
X159 a_898_345# A[12].t2 GND.t117 GND.t116 sky130_fd_pr__nfet_01v8 ad=0.0567 pd=0.69 as=0.1092 ps=1.36 w=0.42 l=0.15
X160 a_391_n935# A[10].t5 a_285_n935# VDD.t247 sky130_fd_pr__pfet_01v8_hvt ad=0.135 pd=1.27 as=0.19 ps=1.38 w=1 l=0.15
X161 a_2830_n935# A[10].t0 GND.t245 GND.t244 sky130_fd_pr__nfet_01v8 ad=0.0567 pd=0.69 as=0.1092 ps=1.36 w=0.42 l=0.15
X162 a_3281_n2437# x3.x9.A VDD.t11 VDD.t10 sky130_fd_pr__pfet_01v8_hvt ad=0.0567 pd=0.69 as=0.1176 ps=1.4 w=0.42 l=0.15
X163 VDD.t72 Z0[2] x6.Y VDD.t71 sky130_fd_pr__pfet_01v8_hvt ad=0.26 pd=2.52 as=0.135 ps=1.27 w=1 l=0.15
X164 x2.x9.A A[11].t0 GND.t213 GND.t212 sky130_fd_pr__nfet_01v8 ad=0.169 pd=1.82 as=0.169 ps=1.82 w=0.65 l=0.15
X165 GND.t173 Y[2].t14 a_1466_n1459# GND.t172 sky130_fd_pr__nfet_01v8 ad=0.11285 pd=1.045 as=0.0693 ps=0.75 w=0.42 l=0.15
X166 VDD.t190 Y[2].t10 a_1459_n1786# VDD.t189 sky130_fd_pr__pfet_01v8_hvt ad=0.15835 pd=1.395 as=0.07665 ps=0.785 w=0.42 l=0.15
X167 GND.t217 A[5].t2 a_898_n2215# GND.t216 sky130_fd_pr__nfet_01v8 ad=0.10025 pd=0.985 as=0.0567 ps=0.69 w=0.42 l=0.15
X168 x4.Z[1] a_1349_n3717# GND.t153 GND.t152 sky130_fd_pr__nfet_01v8 ad=0.182 pd=1.86 as=0.1118 ps=1.04 w=0.65 l=0.15
X169 VDD.t253 A[0].t1 a_2361_n3717# VDD.t252 sky130_fd_pr__pfet_01v8_hvt ad=0.16655 pd=1.39 as=0.0567 ps=0.69 w=0.42 l=0.15
X170 GND.t227 A[3].t3 Z0[2] GND.t226 sky130_fd_pr__nfet_01v8 ad=0.169 pd=1.82 as=0.08775 ps=0.92 w=0.65 l=0.15
X171 x16.A0 a_3281_123# VDD.t31 VDD.t30 sky130_fd_pr__pfet_01v8_hvt ad=0.475 pd=2.95 as=0.16655 ps=1.39 w=1 l=0.15
X172 x3.x4.A A[6].t2 GND.t223 GND.t222 sky130_fd_pr__nfet_01v8 ad=0.08775 pd=0.92 as=0.169 ps=1.82 w=0.65 l=0.15
X173 Y[0].t1 a_2073_n3066# GND.t150 GND.t149 sky130_fd_pr__nfet_01v8 ad=0.169 pd=1.82 as=0.11285 ps=1.045 w=0.65 l=0.15
X174 x16.A1 a_3281_n1157# VDD.t9 VDD.t8 sky130_fd_pr__pfet_01v8_hvt ad=0.475 pd=2.95 as=0.16655 ps=1.39 w=1 l=0.15
X175 VDD.t226 A[5].t4 a_980_n2215# VDD.t225 sky130_fd_pr__pfet_01v8_hvt ad=0.14575 pd=1.335 as=0.0441 ps=0.63 w=0.42 l=0.15
X176 GND.t121 A[12].t0 a_2447_123# GND.t120 sky130_fd_pr__nfet_01v8 ad=0.1118 pd=1.04 as=0.0567 ps=0.69 w=0.42 l=0.15
X177 a_663_n2215# A[6].t4 x3.x4.A VDD.t228 sky130_fd_pr__pfet_01v8_hvt ad=0.105 pd=1.21 as=0.26 ps=2.52 w=1 l=0.15
X178 GND.t72 x2.x4.B a_1435_n1157# GND.t71 sky130_fd_pr__nfet_01v8 ad=0.1118 pd=1.04 as=0.0567 ps=0.69 w=0.42 l=0.15
X179 a_631_n1786# x13.A0 a_417_n1786# VDD.t40 sky130_fd_pr__pfet_01v8_hvt ad=0.07665 pd=0.785 as=0.1932 ps=1.34 w=0.42 l=0.15
X180 GND.t193 Y[3].t8 a_2294_n1459# GND.t192 sky130_fd_pr__nfet_01v8 ad=0.11285 pd=1.045 as=0.0693 ps=0.75 w=0.42 l=0.15
X181 VDD.t204 Y[3].t6 a_2287_n1786# VDD.t203 sky130_fd_pr__pfet_01v8_hvt ad=0.15835 pd=1.395 as=0.07665 ps=0.785 w=0.42 l=0.15
X182 GND.t175 Y[2].t16 a_638_n1459# GND.t174 sky130_fd_pr__nfet_01v8 ad=0.11285 pd=1.045 as=0.0693 ps=0.75 w=0.42 l=0.15
X183 VDD.t188 Y[2].t12 a_631_n1786# VDD.t187 sky130_fd_pr__pfet_01v8_hvt ad=0.15835 pd=1.395 as=0.07665 ps=0.785 w=0.42 l=0.15
X184 a_2193_n313# x6.Y VDD.t60 VDD.t59 sky130_fd_pr__pfet_01v8_hvt ad=0.06615 pd=0.735 as=0.14222 ps=1.335 w=0.42 l=0.15
X185 x3.x4.B a_898_n2215# GND.t97 GND.t96 sky130_fd_pr__nfet_01v8 ad=0.169 pd=1.82 as=0.10025 ps=0.985 w=0.65 l=0.15
X186 Z0[0] a_3281_n3717# GND.t106 GND.t105 sky130_fd_pr__nfet_01v8 ad=0.182 pd=1.86 as=0.1118 ps=1.04 w=0.65 l=0.15
X187 a_2361_n3717# x4.x7.A VDD.t182 VDD.t181 sky130_fd_pr__pfet_01v8_hvt ad=0.0567 pd=0.69 as=0.1176 ps=1.4 w=0.42 l=0.15
X188 a_980_n3495# A[0].t4 a_898_n3495# VDD.t251 sky130_fd_pr__pfet_01v8_hvt ad=0.0441 pd=0.63 as=0.1092 ps=1.36 w=0.42 l=0.15
X189 a_391_n3495# A[2].t5 a_285_n3495# VDD.t260 sky130_fd_pr__pfet_01v8_hvt ad=0.135 pd=1.27 as=0.19 ps=1.38 w=1 l=0.15
X190 a_2933_n571# Z0[2] VDD.t70 VDD.t69 sky130_fd_pr__pfet_01v8_hvt ad=0.0588 pd=0.7 as=0.31245 ps=1.68 w=0.42 l=0.15
X191 VDD.t259 A[7].t4 a_663_n2215# VDD.t258 sky130_fd_pr__pfet_01v8_hvt ad=0.26 pd=2.52 as=0.105 ps=1.21 w=1 l=0.15
X192 x3.x4.B a_898_n2215# VDD.t111 VDD.t110 sky130_fd_pr__pfet_01v8_hvt ad=0.34 pd=2.68 as=0.14575 ps=1.335 w=1 l=0.15
X193 a_2687_n225# Z1[2] x6.Y GND.t48 sky130_fd_pr__nfet_01v8 ad=0.08775 pd=0.92 as=0.169 ps=1.82 w=0.65 l=0.15
X194 a_980_n935# A[8].t4 a_898_n935# VDD.t177 sky130_fd_pr__pfet_01v8_hvt ad=0.0441 pd=0.63 as=0.1092 ps=1.36 w=0.42 l=0.15
X195 a_1349_n1157# x2.x4.A VDD.t85 VDD.t84 sky130_fd_pr__pfet_01v8_hvt ad=0.0567 pd=0.69 as=0.1176 ps=1.4 w=0.42 l=0.15
X196 GND.t53 a_2193_n313# Y[3].t1 GND.t52 sky130_fd_pr__nfet_01v8 ad=0.13165 pd=1.14 as=0.169 ps=1.82 w=0.65 l=0.15
X197 x4.x7.A A[1].t1 VDD.t240 VDD.t239 sky130_fd_pr__pfet_01v8_hvt ad=0.26 pd=2.52 as=0.26 ps=2.52 w=1 l=0.15
X198 Y[1].t1 a_2073_n1786# GND.t95 GND.t94 sky130_fd_pr__nfet_01v8 ad=0.169 pd=1.82 as=0.11285 ps=1.045 w=0.65 l=0.15
X199 VDD.t5 x3.x4.B a_1349_n2437# VDD.t4 sky130_fd_pr__pfet_01v8_hvt ad=0.16655 pd=1.39 as=0.0567 ps=0.69 w=0.42 l=0.15
X200 a_2447_123# x1.x7.A a_2361_123# GND.t31 sky130_fd_pr__nfet_01v8 ad=0.0567 pd=0.69 as=0.1176 ps=1.4 w=0.42 l=0.15
X201 a_751_n313# x8.Y GND.t37 GND.t36 sky130_fd_pr__nfet_01v8 ad=0.0567 pd=0.69 as=0.10025 ps=0.985 w=0.42 l=0.15
X202 VDD.t54 Z1[2] a_2933_n571# VDD.t53 sky130_fd_pr__pfet_01v8_hvt ad=0.0777 pd=0.79 as=0.0588 ps=0.7 w=0.42 l=0.15
X203 GND.t127 x4.x9.B a_3367_n3717# GND.t126 sky130_fd_pr__nfet_01v8 ad=0.1118 pd=1.04 as=0.0567 ps=0.69 w=0.42 l=0.15
X204 Y[0].t0 a_2073_n3066# VDD.t165 VDD.t164 sky130_fd_pr__pfet_01v8_hvt ad=0.26 pd=2.52 as=0.15835 ps=1.395 w=1 l=0.15
X205 Z0[2] A[0].t3 GND.t251 GND.t250 sky130_fd_pr__nfet_01v8 ad=0.11863 pd=1.015 as=0.169 ps=1.82 w=0.65 l=0.15
X206 x14.X a_1245_n1786# VDD.t98 VDD.t97 sky130_fd_pr__pfet_01v8_hvt ad=0.26 pd=2.52 as=0.15835 ps=1.395 w=1 l=0.15
X207 Z1[2] A[6].t3 GND.t221 GND.t220 sky130_fd_pr__nfet_01v8 ad=0.08775 pd=0.92 as=0.08937 ps=0.925 w=0.65 l=0.15
X208 GND.t233 A[1].t3 Z0[2] GND.t232 sky130_fd_pr__nfet_01v8 ad=0.08937 pd=0.925 as=0.11863 ps=1.015 w=0.65 l=0.15
X209 a_391_n2215# A[6].t5 a_285_n2215# VDD.t227 sky130_fd_pr__pfet_01v8_hvt ad=0.135 pd=1.27 as=0.19 ps=1.38 w=1 l=0.15
X210 a_980_n2215# A[4].t4 a_898_n2215# VDD.t213 sky130_fd_pr__pfet_01v8_hvt ad=0.0441 pd=0.63 as=0.1092 ps=1.36 w=0.42 l=0.15
X211 a_1435_n1157# x2.x4.A a_1349_n1157# GND.t73 sky130_fd_pr__nfet_01v8 ad=0.0567 pd=0.69 as=0.1176 ps=1.4 w=0.42 l=0.15
X212 x2.x8.A a_2361_n1157# GND.t13 GND.t12 sky130_fd_pr__nfet_01v8 ad=0.182 pd=1.86 as=0.1118 ps=1.04 w=0.65 l=0.15
X213 GND.t239 A[15].t2 x1.x4.A GND.t238 sky130_fd_pr__nfet_01v8 ad=0.169 pd=1.82 as=0.08775 ps=0.92 w=0.65 l=0.15
X214 a_273_n313# x10.B VDD.t139 VDD.t138 sky130_fd_pr__pfet_01v8_hvt ad=0.0567 pd=0.69 as=0.16655 ps=1.39 w=0.42 l=0.15
X215 GND.t79 x2.x8.A a_2830_n935# GND.t78 sky130_fd_pr__nfet_01v8 ad=0.10025 pd=0.985 as=0.0567 ps=0.69 w=0.42 l=0.15
X216 x4.x9.B a_2830_n3495# GND.t108 GND.t107 sky130_fd_pr__nfet_01v8 ad=0.169 pd=1.82 as=0.10025 ps=0.985 w=0.65 l=0.15
X217 a_2361_n1157# x2.x7.A VDD.t94 VDD.t93 sky130_fd_pr__pfet_01v8_hvt ad=0.0567 pd=0.69 as=0.1176 ps=1.4 w=0.42 l=0.15
X218 a_273_n313# Z3[2] a_447_n207# GND.t22 sky130_fd_pr__nfet_01v8 ad=0.1176 pd=1.4 as=0.0567 ps=0.69 w=0.42 l=0.15
X219 a_3367_n3717# x4.x9.A a_3281_n3717# GND.t104 sky130_fd_pr__nfet_01v8 ad=0.0567 pd=0.69 as=0.1176 ps=1.4 w=0.42 l=0.15
X220 a_285_n3495# A[1].t5 a_203_n3495# VDD.t236 sky130_fd_pr__pfet_01v8_hvt ad=0.19 pd=1.38 as=0.13 ps=1.26 w=1 l=0.15
X221 VDD.t173 A[9].t4 a_980_n935# VDD.t172 sky130_fd_pr__pfet_01v8_hvt ad=0.14575 pd=1.335 as=0.0441 ps=0.63 w=0.42 l=0.15
X222 x13.X a_417_n1786# VDD.t104 VDD.t103 sky130_fd_pr__pfet_01v8_hvt ad=0.26 pd=2.52 as=0.15835 ps=1.395 w=1 l=0.15
X223 x3.x7.A A[5].t0 GND.t219 GND.t218 sky130_fd_pr__nfet_01v8 ad=0.169 pd=1.82 as=0.169 ps=1.82 w=0.65 l=0.15
X224 VDD.t64 Z2[2] x8.Y VDD.t63 sky130_fd_pr__pfet_01v8_hvt ad=0.26 pd=2.52 as=0.26 ps=2.52 w=1 l=0.15
X225 GND.t261 A[7].t2 x3.x4.A GND.t260 sky130_fd_pr__nfet_01v8 ad=0.169 pd=1.82 as=0.08775 ps=0.92 w=0.65 l=0.15
X226 x3.x7.A A[5].t1 VDD.t224 VDD.t223 sky130_fd_pr__pfet_01v8_hvt ad=0.26 pd=2.52 as=0.26 ps=2.52 w=1 l=0.15
X227 VDD.t42 x1.x4.B a_1349_123# VDD.t41 sky130_fd_pr__pfet_01v8_hvt ad=0.16655 pd=1.39 as=0.0567 ps=0.69 w=0.42 l=0.15
X228 x1.x8.A a_2361_123# GND.t20 GND.t19 sky130_fd_pr__nfet_01v8 ad=0.182 pd=1.86 as=0.1118 ps=1.04 w=0.65 l=0.15
X229 a_417_n2739# a_163_n3066# GND.t148 GND.t147 sky130_fd_pr__nfet_01v8 ad=0.0693 pd=0.75 as=0.1449 ps=1.11 w=0.42 l=0.15
X230 a_203_345# A[12].t5 Z3[2] VDD.t132 sky130_fd_pr__pfet_01v8_hvt ad=0.13 pd=1.26 as=0.26 ps=2.52 w=1 l=0.15
X231 x2.x7.A A[9].t1 VDD.t175 VDD.t174 sky130_fd_pr__pfet_01v8_hvt ad=0.26 pd=2.52 as=0.26 ps=2.52 w=1 l=0.15
X232 a_1459_n1786# x3.Z[1] a_1245_n1786# VDD.t100 sky130_fd_pr__pfet_01v8_hvt ad=0.07665 pd=0.785 as=0.1932 ps=1.34 w=0.42 l=0.15
X233 a_898_n2215# A[4].t2 GND.t207 GND.t206 sky130_fd_pr__nfet_01v8 ad=0.0567 pd=0.69 as=0.1092 ps=1.36 w=0.42 l=0.15
X234 a_2073_n1786# x13.X a_2073_n1459# GND.t93 sky130_fd_pr__nfet_01v8 ad=0.09975 pd=0.895 as=0.0693 ps=0.75 w=0.42 l=0.15
X235 x4.Z[1] a_1349_n3717# VDD.t168 VDD.t167 sky130_fd_pr__pfet_01v8_hvt ad=0.475 pd=2.95 as=0.16655 ps=1.39 w=1 l=0.15
X236 GND.t167 A[8].t0 a_2447_n1157# GND.t166 sky130_fd_pr__nfet_01v8 ad=0.1118 pd=1.04 as=0.0567 ps=0.69 w=0.42 l=0.15
X237 VDD.t231 A[3].t5 a_391_n3495# VDD.t230 sky130_fd_pr__pfet_01v8_hvt ad=0.26 pd=2.52 as=0.135 ps=1.27 w=1 l=0.15
X238 a_2287_n1786# x13.X a_2073_n1786# VDD.t107 sky130_fd_pr__pfet_01v8_hvt ad=0.07665 pd=0.785 as=0.1932 ps=1.34 w=0.42 l=0.15
X239 a_1349_n2437# x3.x4.A VDD.t159 VDD.t158 sky130_fd_pr__pfet_01v8_hvt ad=0.0567 pd=0.69 as=0.1176 ps=1.4 w=0.42 l=0.15
X240 x2.x9.A A[11].t1 VDD.t221 VDD.t220 sky130_fd_pr__pfet_01v8_hvt ad=0.26 pd=2.52 as=0.26 ps=2.52 w=1 l=0.15
X241 a_417_n3066# x16.A1 a_345_n3066# VDD.t88 sky130_fd_pr__pfet_01v8_hvt ad=0.1932 pd=1.34 as=0.0441 ps=0.63 w=0.42 l=0.15
X242 a_1435_123# x1.x4.A a_1349_123# GND.t21 sky130_fd_pr__nfet_01v8 ad=0.0567 pd=0.69 as=0.1176 ps=1.4 w=0.42 l=0.15
X243 a_2830_345# A[14].t0 GND.t201 GND.t200 sky130_fd_pr__nfet_01v8 ad=0.0567 pd=0.69 as=0.1092 ps=1.36 w=0.42 l=0.15
X244 a_2830_n3495# A[2].t0 GND.t267 GND.t266 sky130_fd_pr__nfet_01v8 ad=0.0567 pd=0.69 as=0.1092 ps=1.36 w=0.42 l=0.15
X245 VDD.t52 a_2933_n571# Y[4].t0 VDD.t51 sky130_fd_pr__pfet_01v8_hvt ad=0.31245 pd=1.68 as=0.26 ps=2.52 w=1 l=0.15
X246 Z3[2] A[14].t3 GND.t199 GND.t198 sky130_fd_pr__nfet_01v8 ad=0.08775 pd=0.92 as=0.08937 ps=0.925 w=0.65 l=0.15
X247 VDD.t135 A[12].t1 a_2361_123# VDD.t134 sky130_fd_pr__pfet_01v8_hvt ad=0.16655 pd=1.39 as=0.0567 ps=0.69 w=0.42 l=0.15
X248 x1.x9.B a_2830_345# VDD.t33 VDD.t32 sky130_fd_pr__pfet_01v8_hvt ad=0.34 pd=2.68 as=0.14575 ps=1.335 w=1 l=0.15
X249 a_2447_n1157# x2.x7.A a_2361_n1157# GND.t80 sky130_fd_pr__nfet_01v8 ad=0.0567 pd=0.69 as=0.1176 ps=1.4 w=0.42 l=0.15
X250 a_285_n2215# A[5].t5 a_203_n2215# VDD.t222 sky130_fd_pr__pfet_01v8_hvt ad=0.19 pd=1.38 as=0.13 ps=1.26 w=1 l=0.15
X251 x4.x9.A A[3].t0 GND.t229 GND.t228 sky130_fd_pr__nfet_01v8 ad=0.169 pd=1.82 as=0.169 ps=1.82 w=0.65 l=0.15
X252 Z0[0] a_3281_n3717# VDD.t121 VDD.t120 sky130_fd_pr__pfet_01v8_hvt ad=0.475 pd=2.95 as=0.16655 ps=1.39 w=1 l=0.15
X253 x1.x7.A A[13].t0 GND.t141 GND.t140 sky130_fd_pr__nfet_01v8 ad=0.169 pd=1.82 as=0.169 ps=1.82 w=0.65 l=0.15
X254 VDD.t219 A[11].t5 a_391_n935# VDD.t218 sky130_fd_pr__pfet_01v8_hvt ad=0.26 pd=2.52 as=0.135 ps=1.27 w=1 l=0.15
X255 VDD.t90 x2.x9.B a_3281_n1157# VDD.t89 sky130_fd_pr__pfet_01v8_hvt ad=0.16655 pd=1.39 as=0.0567 ps=0.69 w=0.42 l=0.15
X256 a_417_n3066# x16.A0 a_417_n2739# GND.t40 sky130_fd_pr__nfet_01v8 ad=0.09975 pd=0.895 as=0.0693 ps=0.75 w=0.42 l=0.15
X257 GND.t112 x4.x4.B a_1435_n3717# GND.t111 sky130_fd_pr__nfet_01v8 ad=0.1118 pd=1.04 as=0.0567 ps=0.69 w=0.42 l=0.15
X258 x13.A0 a_1349_123# VDD.t17 VDD.t16 sky130_fd_pr__pfet_01v8_hvt ad=0.475 pd=2.95 as=0.16655 ps=1.39 w=1 l=0.15
X259 GND.t67 a_273_n313# Y[2].t1 GND.t66 sky130_fd_pr__nfet_01v8 ad=0.1118 pd=1.04 as=0.182 ps=1.86 w=0.65 l=0.15
X260 VDD.t68 Z2[2] a_2193_n313# VDD.t67 sky130_fd_pr__pfet_01v8_hvt ad=0.0567 pd=0.69 as=0.06615 ps=0.735 w=0.42 l=0.15
X261 GND.t159 A[9].t2 a_898_n935# GND.t158 sky130_fd_pr__nfet_01v8 ad=0.10025 pd=0.985 as=0.0567 ps=0.69 w=0.42 l=0.15
X262 a_2355_n179# x6.Y GND.t51 GND.t50 sky130_fd_pr__nfet_01v8 ad=0.0441 pd=0.63 as=0.13165 ps=1.14 w=0.42 l=0.15
X263 GND.t259 A[7].t3 Z1[2] GND.t258 sky130_fd_pr__nfet_01v8 ad=0.169 pd=1.82 as=0.08775 ps=0.92 w=0.65 l=0.15
X264 VDD.t215 A[4].t1 a_2361_n2437# VDD.t214 sky130_fd_pr__pfet_01v8_hvt ad=0.16655 pd=1.39 as=0.0567 ps=0.69 w=0.42 l=0.15
X265 x3.Z[1] a_1349_n2437# GND.t99 GND.t98 sky130_fd_pr__nfet_01v8 ad=0.182 pd=1.86 as=0.1118 ps=1.04 w=0.65 l=0.15
X266 x2.x4.A A[10].t2 GND.t249 GND.t248 sky130_fd_pr__nfet_01v8 ad=0.08775 pd=0.92 as=0.169 ps=1.82 w=0.65 l=0.15
X267 x3.Z[1] a_1349_n2437# VDD.t113 VDD.t112 sky130_fd_pr__pfet_01v8_hvt ad=0.475 pd=2.95 as=0.16655 ps=1.39 w=1 l=0.15
X268 a_1193_n313# x9.Y VDD.t76 VDD.t75 sky130_fd_pr__pfet_01v8_hvt ad=0.0567 pd=0.69 as=0.16655 ps=1.39 w=0.42 l=0.15
X269 a_2912_n935# A[10].t1 a_2830_n935# VDD.t249 sky130_fd_pr__pfet_01v8_hvt ad=0.0441 pd=0.63 as=0.1092 ps=1.36 w=0.42 l=0.15
X270 VDD.t257 A[7].t5 a_391_n2215# VDD.t256 sky130_fd_pr__pfet_01v8_hvt ad=0.26 pd=2.52 as=0.135 ps=1.27 w=1 l=0.15
X271 GND.t179 Y[2].t7 a_991_n3066# GND.t178 sky130_fd_pr__nfet_01v8 ad=0.1449 pd=1.11 as=0.1092 ps=1.36 w=0.42 l=0.15
X272 x2.x9.B a_2830_n935# VDD.t1 VDD.t0 sky130_fd_pr__pfet_01v8_hvt ad=0.34 pd=2.68 as=0.14575 ps=1.335 w=1 l=0.15
X273 a_1193_n313# Z1[2] a_1367_n207# GND.t47 sky130_fd_pr__nfet_01v8 ad=0.1176 pd=1.4 as=0.0567 ps=0.69 w=0.42 l=0.15
X274 VDD.t35 x1.x8.A a_2912_345# VDD.t34 sky130_fd_pr__pfet_01v8_hvt ad=0.14575 pd=1.335 as=0.0441 ps=0.63 w=0.42 l=0.15
X275 x1.x7.A A[13].t1 VDD.t153 VDD.t152 sky130_fd_pr__pfet_01v8_hvt ad=0.26 pd=2.52 as=0.26 ps=2.52 w=1 l=0.15
X276 x6.Y Z1[2] VDD.t56 VDD.t55 sky130_fd_pr__pfet_01v8_hvt ad=0.135 pd=1.27 as=0.26 ps=2.52 w=1 l=0.15
X277 a_203_n3495# A[0].t5 Z0[2] VDD.t250 sky130_fd_pr__pfet_01v8_hvt ad=0.13 pd=1.26 as=0.26 ps=2.52 w=1 l=0.15
X278 x2.x4.B a_898_n935# GND.t69 GND.t68 sky130_fd_pr__nfet_01v8 ad=0.169 pd=1.82 as=0.10025 ps=0.985 w=0.65 l=0.15
X279 a_2361_n2437# x3.x7.A VDD.t145 VDD.t144 sky130_fd_pr__pfet_01v8_hvt ad=0.0567 pd=0.69 as=0.1176 ps=1.4 w=0.42 l=0.15
X280 Z1[0] a_3281_n2437# GND.t3 GND.t2 sky130_fd_pr__nfet_01v8 ad=0.182 pd=1.86 as=0.1118 ps=1.04 w=0.65 l=0.15
X281 a_2361_123# x1.x7.A VDD.t37 VDD.t36 sky130_fd_pr__pfet_01v8_hvt ad=0.0567 pd=0.69 as=0.1176 ps=1.4 w=0.42 l=0.15
X282 VDD.t198 Y[2].t3 a_991_n3066# VDD.t197 sky130_fd_pr__pfet_01v8_hvt ad=0.0693 pd=0.75 as=0.1176 ps=1.4 w=0.42 l=0.15
X283 VDD.t62 a_2193_n313# Y[3].t0 VDD.t61 sky130_fd_pr__pfet_01v8_hvt ad=0.14222 pd=1.335 as=0.26 ps=2.52 w=1 l=0.15
X284 GND.t181 Y[2].t9 a_163_n3066# GND.t180 sky130_fd_pr__nfet_01v8 ad=0.1449 pd=1.11 as=0.1092 ps=1.36 w=0.42 l=0.15
X285 Z1[0] a_3281_n2437# VDD.t3 VDD.t2 sky130_fd_pr__pfet_01v8_hvt ad=0.475 pd=2.95 as=0.16655 ps=1.39 w=1 l=0.15
X286 x4.x9.B a_2830_n3495# VDD.t123 VDD.t122 sky130_fd_pr__pfet_01v8_hvt ad=0.34 pd=2.68 as=0.14575 ps=1.335 w=1 l=0.15
X287 a_2933_n571# Z3[2] a_3331_n179# GND.t24 sky130_fd_pr__nfet_01v8 ad=0.1092 pd=1.36 as=0.0609 ps=0.71 w=0.42 l=0.15
X288 Y[1].t0 a_2073_n1786# VDD.t109 VDD.t108 sky130_fd_pr__pfet_01v8_hvt ad=0.26 pd=2.52 as=0.15835 ps=1.395 w=1 l=0.15
X289 x13.A0 a_1349_123# GND.t16 GND.t15 sky130_fd_pr__nfet_01v8 ad=0.182 pd=1.86 as=0.1118 ps=1.04 w=0.65 l=0.15
X290 x1.x8.A a_2361_123# VDD.t21 VDD.t20 sky130_fd_pr__pfet_01v8_hvt ad=0.475 pd=2.95 as=0.16655 ps=1.39 w=1 l=0.15
X291 x2.x8.A a_2361_n1157# VDD.t14 VDD.t13 sky130_fd_pr__pfet_01v8_hvt ad=0.475 pd=2.95 as=0.16655 ps=1.39 w=1 l=0.15
X292 VDD.t196 Y[2].t5 a_163_n3066# VDD.t195 sky130_fd_pr__pfet_01v8_hvt ad=0.0693 pd=0.75 as=0.1176 ps=1.4 w=0.42 l=0.15
X293 VDD.t242 A[15].t5 a_391_345# VDD.t241 sky130_fd_pr__pfet_01v8_hvt ad=0.26 pd=2.52 as=0.135 ps=1.27 w=1 l=0.15
X294 x2.x4.B a_898_n935# VDD.t80 VDD.t79 sky130_fd_pr__pfet_01v8_hvt ad=0.34 pd=2.68 as=0.14575 ps=1.335 w=1 l=0.15
X295 GND.t44 x11.B a_751_n313# GND.t43 sky130_fd_pr__nfet_01v8 ad=0.1092 pd=1.36 as=0.0567 ps=0.69 w=0.42 l=0.15
X296 x4.x8.A a_2361_n3717# GND.t110 GND.t109 sky130_fd_pr__nfet_01v8 ad=0.182 pd=1.86 as=0.1118 ps=1.04 w=0.65 l=0.15
X297 a_1435_n3717# x4.x4.A a_1349_n3717# GND.t113 sky130_fd_pr__nfet_01v8 ad=0.0567 pd=0.69 as=0.1176 ps=1.4 w=0.42 l=0.15
X298 GND.t39 a_751_n313# x10.B GND.t38 sky130_fd_pr__nfet_01v8 ad=0.10025 pd=0.985 as=0.169 ps=1.82 w=0.65 l=0.15
X299 GND.t115 x4.x8.A a_2830_n3495# GND.t114 sky130_fd_pr__nfet_01v8 ad=0.10025 pd=0.985 as=0.0567 ps=0.69 w=0.42 l=0.15
R0 A[3].n0 A[3].t4 231.835
R1 A[3].n4 A[3].t1 230.576
R2 A[3].n2 A[3].t5 230.155
R3 A[3].n3 A[3].n2 167.508
R4 A[3].n4 A[3].t0 158.275
R5 A[3].n2 A[3].t3 157.856
R6 A[3].n0 A[3].t2 157.07
R7 A[3].n5 A[3].n4 155.733
R8 A[3].n1 A[3].n0 152
R9 A[3].n6 A[3].n5 15.7314
R10 A[3].n6 A[3].n1 11.6337
R11 A[3].n6 A[3].n3 9.3005
R12 A[3].n3 A[3] 3.93896
R13 A[3].n5 A[3] 2.93383
R14 A[3] A[3].n6 2.02478
R15 A[3].n1 A[3] 2.01193
R16 A[2].n5 A[2].t5 241.536
R17 A[2].n0 A[2].t4 230.363
R18 A[2].n2 A[2].t0 192.639
R19 A[2] A[2].n5 188.722
R20 A[2].n5 A[2].t3 169.237
R21 A[2].n0 A[2].t2 158.064
R22 A[2].n3 A[2].n2 154.058
R23 A[2].n1 A[2].n0 153.792
R24 A[2].n2 A[2].t1 134.799
R25 A[2].n4 A[2].n3 26.9626
R26 A[2].n6 A[2] 14.1005
R27 A[2].n4 A[2].n1 10.2939
R28 A[2].n1 A[2] 4.6085
R29 A[2].n3 A[2] 4.11479
R30 A[2] A[2].n6 1.66214
R31 A[2].n6 A[2].n4 0.00233824
R32 A[1].n5 A[1].t5 241.536
R33 A[1].n0 A[1].t1 230.576
R34 A[1].n2 A[1].t2 206.19
R35 A[1].n5 A[1].t3 169.237
R36 A[1] A[1].n5 167.065
R37 A[1].n0 A[1].t0 158.275
R38 A[1].n1 A[1].n0 155.201
R39 A[1].n3 A[1].n2 152
R40 A[1].n2 A[1].t4 148.35
R41 A[1].n4 A[1].n1 17.349
R42 A[1].n4 A[1].n3 14.9456
R43 A[1].n6 A[1] 11.6278
R44 A[1].n6 A[1].n4 6.9196
R45 A[1].n1 A[1] 3.46717
R46 A[1] A[1].n6 1.27863
R47 A[1].n3 A[1] 0.686214
R48 A[0].n4 A[0].t1 261.887
R49 A[0].n0 A[0].t5 230.155
R50 A[0].n2 A[0].t2 192.639
R51 A[0].n0 A[0].t3 157.856
R52 A[0].n4 A[0].t0 155.847
R53 A[0].n3 A[0].n2 153.601
R54 A[0].n5 A[0].n4 152.768
R55 A[0].n1 A[0].n0 152
R56 A[0].n2 A[0].t4 134.799
R57 A[0].n6 A[0].n5 23.7395
R58 A[0].n6 A[0].n3 16.2762
R59 A[0].n7 A[0].n1 10.5872
R60 A[0].n3 A[0] 4.57193
R61 A[0].n7 A[0].n6 4.53091
R62 A[0].n5 A[0] 4.0965
R63 A[0].n1 A[0] 2.8165
R64 A[0] A[0].n7 0.497524
R65 Y[0].n2 Y[0] 586.72
R66 Y[0].n3 Y[0].n2 585
R67 Y[0].n2 Y[0].n1 585
R68 Y[0].n0 Y[0].t1 214.441
R69 Y[0] Y[0].n3 68.2971
R70 Y[0].n2 Y[0].t0 26.5955
R71 Y[0].n3 Y[0] 11.2721
R72 Y[0] Y[0].n1 11.2721
R73 Y[0].n0 Y[0] 9.79073
R74 Y[0].n1 Y[0] 1.7199
R75 Y[0] Y[0].n0 1.50638
R76 A[7].n1 A[7].t4 231.835
R77 A[7].n0 A[7].t1 230.576
R78 A[7].n3 A[7].t5 230.155
R79 A[7].n4 A[7].n3 167.508
R80 A[7].n0 A[7].t0 158.275
R81 A[7].n3 A[7].t3 157.856
R82 A[7].n1 A[7].t2 157.07
R83 A[7].n6 A[7].n0 155.733
R84 A[7].n2 A[7].n1 152
R85 A[7].n6 A[7].n5 15.7314
R86 A[7].n5 A[7].n2 11.6337
R87 A[7].n5 A[7].n4 9.3005
R88 A[7].n4 A[7] 3.93896
R89 A[7] A[7].n6 2.93383
R90 A[7].n5 A[7] 2.02478
R91 A[7].n2 A[7] 2.01193
R92 A[6].n1 A[6].t5 241.536
R93 A[6].n0 A[6].t4 230.363
R94 A[6].n3 A[6].t0 192.639
R95 A[6] A[6].n1 188.722
R96 A[6].n1 A[6].t3 169.237
R97 A[6].n0 A[6].t2 158.064
R98 A[6].n4 A[6].n3 154.058
R99 A[6].n6 A[6].n0 153.792
R100 A[6].n3 A[6].t1 134.799
R101 A[6].n5 A[6].n4 26.9626
R102 A[6].n2 A[6] 14.1005
R103 A[6].n6 A[6].n5 10.2939
R104 A[6] A[6].n6 4.6085
R105 A[6].n4 A[6] 4.11479
R106 A[6].n2 A[6] 1.66214
R107 A[6].n5 A[6].n2 0.00233824
R108 A[5].n1 A[5].t5 241.536
R109 A[5].n0 A[5].t1 230.576
R110 A[5].n3 A[5].t2 206.19
R111 A[5].n1 A[5].t3 169.237
R112 A[5] A[5].n1 167.065
R113 A[5].n0 A[5].t0 158.275
R114 A[5].n6 A[5].n0 155.201
R115 A[5].n4 A[5].n3 152
R116 A[5].n3 A[5].t4 148.35
R117 A[5].n6 A[5].n5 17.349
R118 A[5].n5 A[5].n4 14.9456
R119 A[5].n2 A[5] 11.6278
R120 A[5].n5 A[5].n2 6.9196
R121 A[5] A[5].n6 3.46717
R122 A[5].n2 A[5] 1.27863
R123 A[5].n4 A[5] 0.686214
R124 A[4].n0 A[4].t1 261.887
R125 A[4].n3 A[4].t5 230.155
R126 A[4].n1 A[4].t2 192.639
R127 A[4].n3 A[4].t3 157.856
R128 A[4].n0 A[4].t0 155.847
R129 A[4].n2 A[4].n1 153.601
R130 A[4].n7 A[4].n0 152.768
R131 A[4].n4 A[4].n3 152
R132 A[4].n1 A[4].t4 134.799
R133 A[4].n7 A[4].n6 23.7395
R134 A[4].n6 A[4].n2 16.2762
R135 A[4].n5 A[4].n4 10.5872
R136 A[4].n2 A[4] 4.57193
R137 A[4].n6 A[4].n5 4.53091
R138 A[4] A[4].n7 4.0965
R139 A[4].n4 A[4] 2.8165
R140 A[4].n5 A[4] 0.497524
R141 Y[1] Y[1].n3 586.72
R142 Y[1].n3 Y[1].n2 585
R143 Y[1].n3 Y[1].n1 585
R144 Y[1] Y[1].t1 215.947
R145 Y[1].n2 Y[1] 68.2971
R146 Y[1].n3 Y[1].t0 26.5955
R147 Y[1].n2 Y[1] 11.2721
R148 Y[1].n0 Y[1] 9.82613
R149 Y[1].n1 Y[1].n0 7.83334
R150 Y[1] Y[1].n0 3.43931
R151 Y[1] Y[1].n1 1.7199
R152 A[11].n1 A[11].t4 231.835
R153 A[11].n0 A[11].t1 230.576
R154 A[11].n3 A[11].t5 230.155
R155 A[11].n4 A[11].n3 167.508
R156 A[11].n0 A[11].t0 158.275
R157 A[11].n3 A[11].t3 157.856
R158 A[11].n1 A[11].t2 157.07
R159 A[11].n6 A[11].n0 155.733
R160 A[11].n2 A[11].n1 152
R161 A[11].n6 A[11].n5 15.7314
R162 A[11].n5 A[11].n2 11.6337
R163 A[11].n5 A[11].n4 9.3005
R164 A[11].n4 A[11] 3.93896
R165 A[11] A[11].n6 2.93383
R166 A[11].n5 A[11] 2.02478
R167 A[11].n2 A[11] 2.01193
R168 A[10].n1 A[10].t5 241.536
R169 A[10].n0 A[10].t4 230.363
R170 A[10].n3 A[10].t0 192.639
R171 A[10] A[10].n1 188.722
R172 A[10].n1 A[10].t3 169.237
R173 A[10].n0 A[10].t2 158.064
R174 A[10].n4 A[10].n3 154.058
R175 A[10].n6 A[10].n0 153.792
R176 A[10].n3 A[10].t1 134.799
R177 A[10].n5 A[10].n4 26.9626
R178 A[10].n2 A[10] 14.1005
R179 A[10].n6 A[10].n5 10.2939
R180 A[10] A[10].n6 4.6085
R181 A[10].n4 A[10] 4.11479
R182 A[10].n2 A[10] 1.66214
R183 A[10].n5 A[10].n2 0.00233824
R184 A[9].n1 A[9].t5 241.536
R185 A[9].n0 A[9].t1 230.576
R186 A[9].n3 A[9].t2 206.19
R187 A[9].n1 A[9].t3 169.237
R188 A[9] A[9].n1 167.065
R189 A[9].n0 A[9].t0 158.275
R190 A[9].n6 A[9].n0 155.201
R191 A[9].n4 A[9].n3 152
R192 A[9].n3 A[9].t4 148.35
R193 A[9].n6 A[9].n5 17.349
R194 A[9].n5 A[9].n4 14.9456
R195 A[9].n2 A[9] 11.6278
R196 A[9].n5 A[9].n2 6.9196
R197 A[9] A[9].n6 3.46717
R198 A[9].n2 A[9] 1.27863
R199 A[9].n4 A[9] 0.686214
R200 A[8].n0 A[8].t1 261.887
R201 A[8].n3 A[8].t5 230.155
R202 A[8].n1 A[8].t2 192.639
R203 A[8].n3 A[8].t3 157.856
R204 A[8].n0 A[8].t0 155.847
R205 A[8].n2 A[8].n1 153.601
R206 A[8].n7 A[8].n0 152.768
R207 A[8].n4 A[8].n3 152
R208 A[8].n1 A[8].t4 134.799
R209 A[8].n7 A[8].n6 23.7395
R210 A[8].n6 A[8].n2 16.2762
R211 A[8].n5 A[8].n4 10.5872
R212 A[8].n2 A[8] 4.57193
R213 A[8].n6 A[8].n5 4.53091
R214 A[8] A[8].n7 4.0965
R215 A[8].n4 A[8] 2.8165
R216 A[8].n5 A[8] 0.497524
R217 Y[4].n5 Y[4] 586.694
R218 Y[4].n6 Y[4].n5 585
R219 Y[4].n5 Y[4].n3 585
R220 Y[4].n0 Y[4].t1 132.451
R221 Y[4].n5 Y[4].t0 26.5955
R222 Y[4].n2 Y[4] 16.5673
R223 Y[4] Y[4].n2 12.3082
R224 Y[4].n4 Y[4].n3 10.0928
R225 Y[4] Y[4].n1 6.4005
R226 Y[4].n1 Y[4].n0 5.4579
R227 Y[4].n1 Y[4] 4.89462
R228 Y[4].n4 Y[4] 4.43127
R229 Y[4] Y[4].n4 3.38874
R230 Y[4].n0 Y[4] 2.40895
R231 Y[4] Y[4].n6 2.21588
R232 Y[4].n6 Y[4].n2 2.21588
R233 Y[4].n3 Y[4] 2.21588
R234 Y[3].n6 Y[3].n5 585
R235 Y[3].n7 Y[3].n6 585
R236 Y[3] Y[3].n1 439.457
R237 Y[3].n11 Y[3].n0 424.671
R238 Y[3].n2 Y[3].t5 329.902
R239 Y[3].n12 Y[3].t9 329.902
R240 Y[3].n1 Y[3].t2 272.062
R241 Y[3].n0 Y[3].t6 272.062
R242 Y[3] Y[3].t1 214.108
R243 Y[3].n1 Y[3].t4 206.19
R244 Y[3].n0 Y[3].t8 206.19
R245 Y[3].n3 Y[3].n2 152
R246 Y[3].n13 Y[3].n12 152
R247 Y[3].n2 Y[3].t3 148.35
R248 Y[3].n12 Y[3].t7 148.35
R249 Y[3].n5 Y[3] 92.1257
R250 Y[3].n10 Y[3].n4 26.8967
R251 Y[3].n6 Y[3].t0 26.5955
R252 Y[3].n9 Y[3].n8 23.1675
R253 Y[3].n11 Y[3].n10 21.9626
R254 Y[3].n3 Y[3] 20.211
R255 Y[3] Y[3].n13 20.211
R256 Y[3] Y[3].n11 14.2345
R257 Y[3].n8 Y[3].n7 10.9387
R258 Y[3].n13 Y[3] 10.7794
R259 Y[3].n4 Y[3] 7.74787
R260 Y[3].n8 Y[3].n5 4.88777
R261 Y[3].n10 Y[3].n9 4.8505
R262 Y[3].n4 Y[3].n3 3.03208
R263 Y[3].n7 Y[3] 1.16414
R264 Y[3].n9 Y[3] 0.063
R265 Y[2].n10 Y[2] 586.253
R266 Y[2].n11 Y[2].n10 585
R267 Y[2] Y[2].n14 439.457
R268 Y[2] Y[2].n18 439.457
R269 Y[2] Y[2].n0 439.457
R270 Y[2] Y[2].n4 439.457
R271 Y[2].n15 Y[2].t7 329.902
R272 Y[2].n19 Y[2].t9 329.902
R273 Y[2].n1 Y[2].t17 329.902
R274 Y[2].n5 Y[2].t15 329.902
R275 Y[2].n9 Y[2].t1 274.06
R276 Y[2].n14 Y[2].t2 272.062
R277 Y[2].n18 Y[2].t4 272.062
R278 Y[2].n0 Y[2].t12 272.062
R279 Y[2].n4 Y[2].t10 272.062
R280 Y[2].n14 Y[2].t6 206.19
R281 Y[2].n18 Y[2].t8 206.19
R282 Y[2].n0 Y[2].t16 206.19
R283 Y[2].n4 Y[2].t14 206.19
R284 Y[2].n16 Y[2].n15 152
R285 Y[2].n20 Y[2].n19 152
R286 Y[2].n2 Y[2].n1 152
R287 Y[2].n6 Y[2].n5 152
R288 Y[2].n15 Y[2].t3 148.35
R289 Y[2].n19 Y[2].t5 148.35
R290 Y[2].n1 Y[2].t13 148.35
R291 Y[2].n5 Y[2].t11 148.35
R292 Y[2].n10 Y[2].t0 46.2955
R293 Y[2].n22 Y[2].n17 21.5192
R294 Y[2].n8 Y[2].n7 21.4001
R295 Y[2].n20 Y[2] 20.211
R296 Y[2].n6 Y[2] 20.211
R297 Y[2].n2 Y[2] 17.4904
R298 Y[2] Y[2].n12 15.3605
R299 Y[2].n17 Y[2] 13.1373
R300 Y[2].n13 Y[2] 12.8005
R301 Y[2].n16 Y[2] 10.7794
R302 Y[2] Y[2].n13 9.90185
R303 Y[2].n8 Y[2].n3 9.30245
R304 Y[2].n22 Y[2].n21 9.3005
R305 Y[2].n21 Y[2] 9.09524
R306 Y[2].n7 Y[2] 9.09524
R307 Y[2].n11 Y[2] 8.2092
R308 Y[2].n3 Y[2] 7.63127
R309 Y[2].n17 Y[2].n16 7.07418
R310 Y[2].n23 Y[2] 5.82624
R311 Y[2].n23 Y[2] 5.69633
R312 Y[2].n13 Y[2] 4.6085
R313 Y[2].n9 Y[2] 2.86947
R314 Y[2] Y[2].n9 2.5605
R315 Y[2].n12 Y[2] 2.0485
R316 Y[2].n21 Y[2].n20 1.68471
R317 Y[2].n7 Y[2].n6 1.68471
R318 Y[2] Y[2].n11 1.25267
R319 Y[2].n12 Y[2] 1.11354
R320 Y[2] Y[2].n22 0.702714
R321 Y[2] Y[2].n8 0.672375
R322 Y[2] Y[2].n23 0.426281
R323 Y[2].n3 Y[2].n2 0.246654
R324 A[15].n0 A[15].t4 231.835
R325 A[15].n4 A[15].t1 230.576
R326 A[15].n2 A[15].t5 230.155
R327 A[15].n3 A[15].n2 167.508
R328 A[15].n4 A[15].t0 158.275
R329 A[15].n2 A[15].t3 157.856
R330 A[15].n0 A[15].t2 157.07
R331 A[15].n5 A[15].n4 155.733
R332 A[15].n1 A[15].n0 152
R333 A[15].n6 A[15].n5 15.7314
R334 A[15].n6 A[15].n1 11.6337
R335 A[15].n6 A[15].n3 9.3005
R336 A[15].n3 A[15] 3.93896
R337 A[15].n5 A[15] 2.93383
R338 A[15] A[15].n6 2.02478
R339 A[15].n1 A[15] 2.01193
R340 A[14].n5 A[14].t5 241.536
R341 A[14].n0 A[14].t4 230.363
R342 A[14].n2 A[14].t0 192.639
R343 A[14] A[14].n5 188.722
R344 A[14].n5 A[14].t3 169.237
R345 A[14].n0 A[14].t2 158.064
R346 A[14].n3 A[14].n2 154.058
R347 A[14].n1 A[14].n0 153.792
R348 A[14].n2 A[14].t1 134.799
R349 A[14].n4 A[14].n3 26.9626
R350 A[14].n6 A[14] 14.1005
R351 A[14].n4 A[14].n1 10.2939
R352 A[14].n1 A[14] 4.6085
R353 A[14].n3 A[14] 4.11479
R354 A[14] A[14].n6 1.66214
R355 A[14].n6 A[14].n4 0.00233824
R356 A[13].n5 A[13].t5 241.536
R357 A[13].n0 A[13].t1 230.576
R358 A[13].n2 A[13].t2 206.19
R359 A[13].n5 A[13].t3 169.237
R360 A[13] A[13].n5 167.065
R361 A[13].n0 A[13].t0 158.275
R362 A[13].n1 A[13].n0 155.201
R363 A[13].n3 A[13].n2 152
R364 A[13].n2 A[13].t4 148.35
R365 A[13].n4 A[13].n1 17.349
R366 A[13].n4 A[13].n3 14.9456
R367 A[13].n6 A[13] 11.6278
R368 A[13].n6 A[13].n4 6.9196
R369 A[13].n1 A[13] 3.46717
R370 A[13] A[13].n6 1.27863
R371 A[13].n3 A[13] 0.686214
R372 A[12].n4 A[12].t1 261.887
R373 A[12].n0 A[12].t5 230.155
R374 A[12].n2 A[12].t2 192.639
R375 A[12].n0 A[12].t3 157.856
R376 A[12].n4 A[12].t0 155.847
R377 A[12].n3 A[12].n2 153.601
R378 A[12].n5 A[12].n4 152.768
R379 A[12].n1 A[12].n0 152
R380 A[12].n2 A[12].t4 134.799
R381 A[12].n6 A[12].n5 23.7395
R382 A[12].n6 A[12].n3 16.2762
R383 A[12].n7 A[12].n1 10.5872
R384 A[12].n3 A[12] 4.57193
R385 A[12].n7 A[12].n6 4.53091
R386 A[12].n5 A[12] 4.0965
R387 A[12].n1 A[12] 2.8165
R388 A[12] A[12].n7 0.497524
R389 VDD.n177 VDD.t30 757.668
R390 VDD.n53 VDD.t120 757.668
R391 VDD.t2 VDD.n32 757.668
R392 VDD.n309 VDD.n308 717.729
R393 VDD.n256 VDD.t58 675.293
R394 VDD.n276 VDD.t29 675.293
R395 VDD.n235 VDD.t23 675.293
R396 VDD.n165 VDD.t37 675.293
R397 VDD.n184 VDD.t39 675.293
R398 VDD.n104 VDD.t129 675.293
R399 VDD.n75 VDD.t182 675.293
R400 VDD.n60 VDD.t119 675.293
R401 VDD.n264 VDD.t85 675.293
R402 VDD.n316 VDD.t94 675.293
R403 VDD.n291 VDD.t87 675.293
R404 VDD.n424 VDD.t159 675.293
R405 VDD.n399 VDD.t145 675.293
R406 VDD.n4 VDD.t11 675.293
R407 VDD.n345 VDD.t25 662.841
R408 VDD.n88 VDD.n87 629.801
R409 VDD.n146 VDD.n108 629.801
R410 VDD.n129 VDD.n125 629.801
R411 VDD.n411 VDD.n396 629.801
R412 VDD.n466 VDD.n428 629.801
R413 VDD.n449 VDD.n445 629.801
R414 VDD.n331 VDD.n305 611.646
R415 VDD.n290 VDD.n289 599.74
R416 VDD VDD.t32 547.509
R417 VDD VDD.t18 547.509
R418 VDD VDD.t122 547.509
R419 VDD.t160 VDD 547.509
R420 VDD VDD.t152 503.115
R421 VDD VDD.t245 503.115
R422 VDD VDD.t20 494.238
R423 VDD VDD.t16 494.238
R424 VDD VDD.t243 411.372
R425 VDD VDD.t241 366.978
R426 VDD VDD.t124 366.183
R427 VDD.t142 VDD 366.183
R428 VDD.n121 VDD.t231 341.93
R429 VDD.n279 VDD.t219 341.93
R430 VDD.n441 VDD.t257 341.93
R431 VDD.n218 VDD.t242 341.928
R432 VDD.n378 VDD.n262 325.627
R433 VDD.n361 VDD.n281 325.627
R434 VDD.n213 VDD.n212 325.627
R435 VDD.n197 VDD.n167 325.627
R436 VDD.n175 VDD.n174 325.627
R437 VDD.n101 VDD.n100 325.627
R438 VDD.n74 VDD.n43 325.627
R439 VDD.n51 VDD.n50 325.627
R440 VDD.n258 VDD.n257 325.627
R441 VDD.n313 VDD.n311 325.627
R442 VDD.n349 VDD.n348 325.627
R443 VDD.n421 VDD.n420 325.627
R444 VDD.n8 VDD.n7 325.627
R445 VDD.n28 VDD.n27 325.627
R446 VDD.t30 VDD.t48 319.627
R447 VDD.t20 VDD.t134 319.627
R448 VDD.t16 VDD.t41 319.627
R449 VDD.t120 VDD.t140 319.627
R450 VDD.t146 VDD.t2 319.627
R451 VDD.n229 VDD.n228 315.303
R452 VDD.n190 VDD.n171 315.303
R453 VDD.n112 VDD.n110 315.303
R454 VDD.n66 VDD.n47 315.303
R455 VDD.n269 VDD.n268 315.303
R456 VDD.n300 VDD.n298 315.303
R457 VDD.n432 VDD.n430 315.303
R458 VDD.n17 VDD.n16 315.303
R459 VDD.n271 VDD.n270 315.301
R460 VDD.t211 VDD 313.707
R461 VDD.t152 VDD 313.707
R462 VDD.t245 VDD 313.707
R463 VDD.t133 VDD 313.707
R464 VDD.t209 VDD.t151 313.707
R465 VDD.t262 VDD 313.707
R466 VDD VDD.t229 313.707
R467 VDD.n338 VDD.n295 310.5
R468 VDD.t38 VDD 298.911
R469 VDD.t36 VDD 298.911
R470 VDD.t22 VDD 298.911
R471 VDD.t118 VDD 298.911
R472 VDD VDD.t10 298.911
R473 VDD.t32 VDD.t34 287.072
R474 VDD.t18 VDD.t154 287.072
R475 VDD.t122 VDD.t130 287.072
R476 VDD.t114 VDD.t160 287.072
R477 VDD.n354 VDD.n353 265.296
R478 VDD.n243 VDD.t246 255.905
R479 VDD.n163 VDD.t153 255.905
R480 VDD.n94 VDD.t235 255.905
R481 VDD.n85 VDD.t240 255.905
R482 VDD.n251 VDD.t221 255.905
R483 VDD.n321 VDD.t175 255.905
R484 VDD.n414 VDD.t255 255.905
R485 VDD.n405 VDD.t224 255.905
R486 VDD.n320 VDD.t64 255.904
R487 VDD.n255 VDD.t74 255.904
R488 VDD.n332 VDD.t56 249.362
R489 VDD.t48 VDD.t38 248.599
R490 VDD.t134 VDD.t36 248.599
R491 VDD.t41 VDD.t22 248.599
R492 VDD.t241 VDD.t209 248.599
R493 VDD.t140 VDD.t118 248.599
R494 VDD.t10 VDD.t146 248.599
R495 VDD.n297 VDD.t72 247.394
R496 VDD.n223 VDD.t244 243.512
R497 VDD.n117 VDD.t233 243.512
R498 VDD.n274 VDD.t217 243.512
R499 VDD.n437 VDD.t259 243.512
R500 VDD.t151 VDD.t132 242.679
R501 VDD.n80 VDD.n41 235.248
R502 VDD.n93 VDD.n92 235.248
R503 VDD.n140 VDD.n115 235.248
R504 VDD.n498 VDD.n34 235.248
R505 VDD.n413 VDD.n412 235.248
R506 VDD.n460 VDD.n435 235.248
R507 VDD.t124 VDD.n42 213.119
R508 VDD.n356 VDD.n355 213.119
R509 VDD.n33 VDD.t142 213.119
R510 VDD.t34 VDD.t211 213.084
R511 VDD.t154 VDD.t133 213.084
R512 VDD.t243 VDD.t210 213.084
R513 VDD.t130 VDD.t262 213.084
R514 VDD.t229 VDD.t114 213.084
R515 VDD.t132 VDD 192.369
R516 VDD.t210 VDD 189.409
R517 VDD VDD.t230 177.946
R518 VDD VDD.t256 177.946
R519 VDD VDD.t6 176.512
R520 VDD VDD.t97 176.512
R521 VDD.t180 VDD.t239 159.291
R522 VDD.t107 VDD.t223 159.291
R523 VDD.t79 VDD.t136 157.856
R524 VDD.t124 VDD.t252 154.986
R525 VDD.t178 VDD.t13 154.986
R526 VDD.t142 VDD.t214 154.986
R527 VDD.t234 VDD 152.115
R528 VDD.t251 VDD 152.115
R529 VDD VDD.t174 152.115
R530 VDD VDD.t220 152.115
R531 VDD.t254 VDD 152.115
R532 VDD.t213 VDD 152.115
R533 VDD VDD.t249 150.68
R534 VDD.t239 VDD.t166 147.81
R535 VDD.t223 VDD.t15 147.81
R536 VDD.t89 VDD.n354 147.702
R537 VDD.t128 VDD 144.94
R538 VDD.t158 VDD 144.94
R539 VDD.t220 VDD.t63 140.635
R540 VDD.t91 VDD.t0 139.2
R541 VDD.t199 VDD.t207 137.764
R542 VDD.t95 VDD.t201 137.764
R543 VDD.t61 VDD.t59 136.329
R544 VDD VDD.t232 134.894
R545 VDD VDD.t258 134.894
R546 VDD.t82 VDD 130.589
R547 VDD VDD.t79 130.589
R548 VDD VDD.t148 127.719
R549 VDD.t156 VDD.t73 127.719
R550 VDD VDD.t99 127.719
R551 VDD.n41 VDD.t206 123.507
R552 VDD.n92 VDD.t192 123.507
R553 VDD.n115 VDD.t194 123.507
R554 VDD.n34 VDD.t204 123.507
R555 VDD.n412 VDD.t190 123.507
R556 VDD.n435 VDD.t188 123.507
R557 VDD.t69 VDD.t53 123.415
R558 VDD.t55 VDD.t71 120.544
R559 VDD.t216 VDD.t45 117.674
R560 VDD.t176 VDD.t171 117.674
R561 VDD.n295 VDD.t70 117.451
R562 VDD.n262 VDD.t76 116.341
R563 VDD.n281 VDD.t139 116.341
R564 VDD.n212 VDD.t42 116.341
R565 VDD.n167 VDD.t135 116.341
R566 VDD.n174 VDD.t49 116.341
R567 VDD.n100 VDD.t127 116.341
R568 VDD.n43 VDD.t253 116.341
R569 VDD.n50 VDD.t141 116.341
R570 VDD.n257 VDD.t83 116.341
R571 VDD.n311 VDD.t179 116.341
R572 VDD.n348 VDD.t90 116.341
R573 VDD.n420 VDD.t5 116.341
R574 VDD.n7 VDD.t215 116.341
R575 VDD.n27 VDD.t147 116.341
R576 VDD.t73 VDD 111.934
R577 VDD.t136 VDD 107.629
R578 VDD.t148 VDD.t149 103.323
R579 VDD.t169 VDD.t197 103.323
R580 VDD.t237 VDD.t251 103.323
R581 VDD.t63 VDD 103.323
R582 VDD.t248 VDD.t216 103.323
R583 VDD.t99 VDD.t101 103.323
R584 VDD.t110 VDD.t183 103.323
R585 VDD.t225 VDD.t213 103.323
R586 VDD.t193 VDD.t261 101.888
R587 VDD.t187 VDD.t228 101.888
R588 VDD VDD.t199 99.0186
R589 VDD VDD.t67 99.0186
R590 VDD VDD.t95 99.0186
R591 VDD.t75 VDD.t84 97.5836
R592 VDD.n270 VDD.t44 96.1553
R593 VDD.n228 VDD.t155 96.1553
R594 VDD.n171 VDD.t35 96.1553
R595 VDD.n110 VDD.t238 96.1553
R596 VDD.n47 VDD.t131 96.1553
R597 VDD.n268 VDD.t173 96.1553
R598 VDD.n298 VDD.t92 96.1553
R599 VDD.n430 VDD.t226 96.1553
R600 VDD.n16 VDD.t115 96.1553
R601 VDD.t57 VDD 96.1485
R602 VDD.t28 VDD 96.1485
R603 VDD.t50 VDD.t172 94.7135
R604 VDD.t43 VDD.t177 94.7135
R605 VDD.n308 VDD.t60 93.81
R606 VDD.t167 VDD.t191 93.2784
R607 VDD.t250 VDD 93.2784
R608 VDD.t112 VDD.t189 93.2784
R609 VDD.t212 VDD 93.2784
R610 VDD VDD.t248 91.8434
R611 VDD.n289 VDD.t66 86.7743
R612 VDD.n289 VDD.t54 86.7743
R613 VDD.n87 VDD.t200 86.7743
R614 VDD.n108 VDD.t150 86.7743
R615 VDD.n125 VDD.t163 86.7743
R616 VDD.n396 VDD.t96 86.7743
R617 VDD.n428 VDD.t102 86.7743
R618 VDD.n445 VDD.t106 86.7743
R619 VDD.t126 VDD.t12 86.1032
R620 VDD.t162 VDD.t236 86.1032
R621 VDD.t4 VDD.t100 86.1032
R622 VDD.t105 VDD.t222 86.1032
R623 VDD VDD.t180 84.6682
R624 VDD VDD.t107 84.6682
R625 VDD.t230 VDD.t88 83.2331
R626 VDD.t256 VDD.t81 83.2331
R627 VDD.t181 VDD.t205 81.7981
R628 VDD.t45 VDD 81.7981
R629 VDD.t144 VDD.t203 81.7981
R630 VDD.t218 VDD.t28 80.363
R631 VDD.t247 VDD.t138 80.363
R632 VDD.t171 VDD.t77 77.4929
R633 VDD VDD.t65 76.0579
R634 VDD.t86 VDD.t24 74.6229
R635 VDD.t93 VDD.t26 74.6229
R636 VDD.t77 VDD.t247 74.6229
R637 VDD.t53 VDD 73.1878
R638 VDD.t249 VDD.t51 73.1878
R639 VDD.t174 VDD.t61 73.1878
R640 VDD.t65 VDD.t86 68.8827
R641 VDD.t0 VDD.t69 68.8827
R642 VDD.t13 VDD.t55 68.8827
R643 VDD.n355 VDD.t176 68.8827
R644 VDD.n87 VDD.t208 68.0124
R645 VDD.n108 VDD.t198 68.0124
R646 VDD.n125 VDD.t196 68.0124
R647 VDD.n396 VDD.t202 68.0124
R648 VDD.n428 VDD.t184 68.0124
R649 VDD.n445 VDD.t186 68.0124
R650 VDD.t260 VDD.t162 66.0126
R651 VDD.t195 VDD.t250 66.0126
R652 VDD.t227 VDD.t105 66.0126
R653 VDD.t185 VDD.t212 66.0126
R654 VDD.n305 VDD.t27 63.3219
R655 VDD.n305 VDD.t68 63.3219
R656 VDD.t205 VDD 63.1425
R657 VDD.t203 VDD 63.1425
R658 VDD.t191 VDD.t126 61.7074
R659 VDD.t189 VDD.t4 61.7074
R660 VDD VDD.t43 57.4023
R661 VDD VDD.t181 54.5322
R662 VDD VDD.t144 54.5322
R663 VDD.t236 VDD.t195 51.6621
R664 VDD.t222 VDD.t185 51.6621
R665 VDD.t71 VDD 50.2271
R666 VDD VDD.t75 47.357
R667 VDD.t252 VDD.t164 45.9219
R668 VDD.t261 VDD.t47 45.9219
R669 VDD.t47 VDD 45.9219
R670 VDD.t67 VDD.t93 45.9219
R671 VDD.t214 VDD.t108 45.9219
R672 VDD.t228 VDD.t40 45.9219
R673 VDD.t40 VDD 45.9219
R674 VDD VDD.t116 44.4869
R675 VDD.t24 VDD 44.4869
R676 VDD.t26 VDD 44.4869
R677 VDD VDD.t103 44.4869
R678 VDD.n128 VDD.n127 43.9358
R679 VDD.n357 VDD.n285 43.9358
R680 VDD.n448 VDD.n447 43.9358
R681 VDD VDD.t167 43.0519
R682 VDD VDD.t112 43.0519
R683 VDD.n295 VDD.t52 42.3555
R684 VDD.n126 VDD.n123 42.303
R685 VDD.n446 VDD.n443 42.303
R686 VDD.t138 VDD.t218 40.1818
R687 VDD.t88 VDD.t260 37.3117
R688 VDD.t81 VDD.t227 37.3117
R689 VDD.t197 VDD.t237 35.8766
R690 VDD.t183 VDD.t225 35.8766
R691 VDD.n340 VDD.n339 34.6358
R692 VDD.n331 VDD.n330 34.6358
R693 VDD.n326 VDD.n325 34.6358
R694 VDD.n389 VDD.n249 34.6358
R695 VDD.n389 VDD.n388 34.6358
R696 VDD.n388 VDD.n250 34.6358
R697 VDD.n384 VDD.n383 34.6358
R698 VDD.n380 VDD.n379 34.6358
R699 VDD.n377 VDD.n263 34.6358
R700 VDD.n373 VDD.n263 34.6358
R701 VDD.n373 VDD.n372 34.6358
R702 VDD.n368 VDD.n367 34.6358
R703 VDD.n367 VDD.n366 34.6358
R704 VDD.n363 VDD.n362 34.6358
R705 VDD.n360 VDD.n282 34.6358
R706 VDD.n222 VDD.n221 34.6358
R707 VDD.n227 VDD.n216 34.6358
R708 VDD.n234 VDD.n214 34.6358
R709 VDD.n230 VDD.n214 34.6358
R710 VDD.n237 VDD.n236 34.6358
R711 VDD.n242 VDD.n241 34.6358
R712 VDD.n241 VDD.n210 34.6358
R713 VDD.n209 VDD.n208 34.6358
R714 VDD.n244 VDD.n209 34.6358
R715 VDD.n204 VDD.n203 34.6358
R716 VDD.n205 VDD.n204 34.6358
R717 VDD.n199 VDD.n198 34.6358
R718 VDD.n192 VDD.n191 34.6358
R719 VDD.n192 VDD.n168 34.6358
R720 VDD.n196 VDD.n168 34.6358
R721 VDD.n185 VDD.n172 34.6358
R722 VDD.n189 VDD.n172 34.6358
R723 VDD.n183 VDD.n182 34.6358
R724 VDD.n179 VDD.n178 34.6358
R725 VDD.n491 VDD.n81 34.6358
R726 VDD.n491 VDD.n490 34.6358
R727 VDD.n490 VDD.n82 34.6358
R728 VDD.n486 VDD.n82 34.6358
R729 VDD.n486 VDD.n485 34.6358
R730 VDD.n159 VDD.n158 34.6358
R731 VDD.n158 VDD.n157 34.6358
R732 VDD.n154 VDD.n153 34.6358
R733 VDD.n153 VDD.n152 34.6358
R734 VDD.n152 VDD.n99 34.6358
R735 VDD.n148 VDD.n99 34.6358
R736 VDD.n148 VDD.n147 34.6358
R737 VDD.n145 VDD.n109 34.6358
R738 VDD.n141 VDD.n109 34.6358
R739 VDD.n139 VDD.n116 34.6358
R740 VDD.n135 VDD.n116 34.6358
R741 VDD.n135 VDD.n134 34.6358
R742 VDD.n134 VDD.n120 34.6358
R743 VDD.n130 VDD.n120 34.6358
R744 VDD.n123 VDD.n122 34.6358
R745 VDD.n119 VDD.n118 34.6358
R746 VDD.n114 VDD.n113 34.6358
R747 VDD.n106 VDD.n105 34.6358
R748 VDD.n111 VDD.n106 34.6358
R749 VDD.n103 VDD.n102 34.6358
R750 VDD.n96 VDD.n95 34.6358
R751 VDD.n97 VDD.n96 34.6358
R752 VDD.n89 VDD.n86 34.6358
R753 VDD.n90 VDD.n89 34.6358
R754 VDD.n83 VDD.n40 34.6358
R755 VDD.n84 VDD.n83 34.6358
R756 VDD.n77 VDD.n76 34.6358
R757 VDD.n68 VDD.n67 34.6358
R758 VDD.n68 VDD.n44 34.6358
R759 VDD.n73 VDD.n44 34.6358
R760 VDD.n61 VDD.n48 34.6358
R761 VDD.n65 VDD.n48 34.6358
R762 VDD.n59 VDD.n58 34.6358
R763 VDD.n55 VDD.n54 34.6358
R764 VDD.n284 VDD.n283 34.6358
R765 VDD.n285 VDD.n284 34.6358
R766 VDD.n278 VDD.n277 34.6358
R767 VDD.n273 VDD.n272 34.6358
R768 VDD.n266 VDD.n265 34.6358
R769 VDD.n267 VDD.n266 34.6358
R770 VDD.n260 VDD.n259 34.6358
R771 VDD.n253 VDD.n252 34.6358
R772 VDD.n254 VDD.n253 34.6358
R773 VDD.n323 VDD.n322 34.6358
R774 VDD.n322 VDD.n248 34.6358
R775 VDD.n318 VDD.n317 34.6358
R776 VDD.n319 VDD.n318 34.6358
R777 VDD.n315 VDD.n314 34.6358
R778 VDD.n302 VDD.n301 34.6358
R779 VDD.n303 VDD.n302 34.6358
R780 VDD.n312 VDD.n303 34.6358
R781 VDD.n293 VDD.n292 34.6358
R782 VDD.n299 VDD.n293 34.6358
R783 VDD.n347 VDD.n288 34.6358
R784 VDD.n350 VDD.n286 34.6358
R785 VDD.n497 VDD.n35 34.6358
R786 VDD.n401 VDD.n35 34.6358
R787 VDD.n401 VDD.n397 34.6358
R788 VDD.n409 VDD.n397 34.6358
R789 VDD.n410 VDD.n409 34.6358
R790 VDD.n479 VDD.n478 34.6358
R791 VDD.n478 VDD.n477 34.6358
R792 VDD.n474 VDD.n473 34.6358
R793 VDD.n473 VDD.n472 34.6358
R794 VDD.n472 VDD.n419 34.6358
R795 VDD.n468 VDD.n419 34.6358
R796 VDD.n468 VDD.n467 34.6358
R797 VDD.n465 VDD.n429 34.6358
R798 VDD.n461 VDD.n429 34.6358
R799 VDD.n459 VDD.n436 34.6358
R800 VDD.n455 VDD.n436 34.6358
R801 VDD.n455 VDD.n454 34.6358
R802 VDD.n454 VDD.n440 34.6358
R803 VDD.n450 VDD.n440 34.6358
R804 VDD.n443 VDD.n442 34.6358
R805 VDD.n439 VDD.n438 34.6358
R806 VDD.n434 VDD.n433 34.6358
R807 VDD.n426 VDD.n425 34.6358
R808 VDD.n431 VDD.n426 34.6358
R809 VDD.n423 VDD.n422 34.6358
R810 VDD.n416 VDD.n415 34.6358
R811 VDD.n417 VDD.n416 34.6358
R812 VDD.n407 VDD.n406 34.6358
R813 VDD.n406 VDD.n394 34.6358
R814 VDD.n403 VDD.n400 34.6358
R815 VDD.n404 VDD.n403 34.6358
R816 VDD.n36 VDD.n1 34.6358
R817 VDD.n15 VDD.n14 34.6358
R818 VDD.n14 VDD.n10 34.6358
R819 VDD.n10 VDD.n9 34.6358
R820 VDD.n22 VDD.n21 34.6358
R821 VDD.n21 VDD.n5 34.6358
R822 VDD.n26 VDD.n25 34.6358
R823 VDD.n29 VDD.n2 34.6358
R824 VDD.t12 VDD.t128 34.4416
R825 VDD.t149 VDD.t169 34.4416
R826 VDD.t59 VDD 34.4416
R827 VDD.t100 VDD.t158 34.4416
R828 VDD.t101 VDD.t110 34.4416
R829 VDD.n372 VDD.n271 34.2593
R830 VDD.n229 VDD.n227 34.2593
R831 VDD.n191 VDD.n190 34.2593
R832 VDD.n113 VDD.n112 34.2593
R833 VDD.n67 VDD.n66 34.2593
R834 VDD.n272 VDD.n269 34.2593
R835 VDD.n301 VDD.n300 34.2593
R836 VDD.n433 VDD.n432 34.2593
R837 VDD.n17 VDD.n15 34.2593
R838 VDD.n80 VDD.n79 33.8829
R839 VDD.n157 VDD.n93 33.8829
R840 VDD.n141 VDD.n140 33.8829
R841 VDD.n499 VDD.n498 33.8829
R842 VDD.n477 VDD.n413 33.8829
R843 VDD.n461 VDD.n460 33.8829
R844 VDD.t51 VDD.t91 30.1365
R845 VDD.n41 VDD.t165 28.752
R846 VDD.n92 VDD.t7 28.752
R847 VDD.n115 VDD.t117 28.752
R848 VDD.n34 VDD.t109 28.752
R849 VDD.n412 VDD.t98 28.752
R850 VDD.n435 VDD.t104 28.752
R851 VDD.n212 VDD.t17 28.4453
R852 VDD.n167 VDD.t21 28.4453
R853 VDD.n174 VDD.t31 28.4453
R854 VDD.n100 VDD.t168 28.4453
R855 VDD.n43 VDD.t125 28.4453
R856 VDD.n50 VDD.t121 28.4453
R857 VDD.n257 VDD.t157 28.4453
R858 VDD.n311 VDD.t14 28.4453
R859 VDD.n348 VDD.t9 28.4453
R860 VDD.n420 VDD.t113 28.4453
R861 VDD.n7 VDD.t143 28.4453
R862 VDD.n27 VDD.t3 28.4453
R863 VDD.n262 VDD.t137 28.4453
R864 VDD.n281 VDD.t78 28.4453
R865 VDD.n344 VDD.n290 28.2358
R866 VDD.n338 VDD.n337 27.4829
R867 VDD.n330 VDD.n309 27.4829
R868 VDD.n308 VDD.t62 26.9729
R869 VDD.n333 VDD.n332 25.977
R870 VDD.n122 VDD.n121 25.977
R871 VDD.n283 VDD.n279 25.977
R872 VDD.n442 VDD.n441 25.977
R873 VDD.n270 VDD.t46 25.6105
R874 VDD.n228 VDD.t19 25.6105
R875 VDD.n171 VDD.t33 25.6105
R876 VDD.n110 VDD.t170 25.6105
R877 VDD.n47 VDD.t123 25.6105
R878 VDD.n268 VDD.t80 25.6105
R879 VDD.n298 VDD.t1 25.6105
R880 VDD.n430 VDD.t111 25.6105
R881 VDD.n16 VDD.t161 25.6105
R882 VDD.n333 VDD.n297 24.4711
R883 VDD.n223 VDD.n216 24.4711
R884 VDD.n117 VDD.n114 24.4711
R885 VDD.n274 VDD.n273 24.4711
R886 VDD.n437 VDD.n434 24.4711
R887 VDD VDD.t156 24.3963
R888 VDD.n355 VDD 24.3963
R889 VDD.n337 VDD.n297 23.7181
R890 VDD.n356 VDD.n282 23.7181
R891 VDD.n221 VDD.n218 23.7181
R892 VDD.n178 VDD.n177 23.7181
R893 VDD.n79 VDD.n42 23.7181
R894 VDD.n121 VDD.n119 23.7181
R895 VDD.n54 VDD.n53 23.7181
R896 VDD.n279 VDD.n278 23.7181
R897 VDD.n353 VDD.n286 23.7181
R898 VDD.n499 VDD.n33 23.7181
R899 VDD.n441 VDD.n439 23.7181
R900 VDD.n32 VDD.n2 23.7181
R901 VDD.t84 VDD.t57 22.9612
R902 VDD.n326 VDD.n309 22.5887
R903 VDD.t164 VDD 20.0911
R904 VDD.t6 VDD 20.0911
R905 VDD.t116 VDD 20.0911
R906 VDD.t108 VDD 20.0911
R907 VDD.t97 VDD 20.0911
R908 VDD.t103 VDD 20.0911
R909 VDD.n345 VDD.n344 19.9534
R910 VDD.n223 VDD.n222 19.9534
R911 VDD.n118 VDD.n117 19.9534
R912 VDD.n277 VDD.n274 19.9534
R913 VDD.n438 VDD.n437 19.9534
R914 VDD.n485 VDD.n88 17.3181
R915 VDD.n159 VDD.n88 17.3181
R916 VDD.n147 VDD.n146 17.3181
R917 VDD.n146 VDD.n145 17.3181
R918 VDD.n130 VDD.n129 17.3181
R919 VDD.n129 VDD.n128 17.3181
R920 VDD.n411 VDD.n410 17.3181
R921 VDD.n479 VDD.n411 17.3181
R922 VDD.n467 VDD.n466 17.3181
R923 VDD.n466 VDD.n465 17.3181
R924 VDD.n450 VDD.n449 17.3181
R925 VDD.n449 VDD.n448 17.3181
R926 VDD.n339 VDD.n338 16.9417
R927 VDD.n340 VDD.n290 16.1887
R928 VDD.n332 VDD.n331 12.8005
R929 VDD.n483 VDD.n482 11.8775
R930 VDD.n494 VDD.n493 11.8767
R931 VDD.n201 VDD.n38 11.8601
R932 VDD.n392 VDD.n246 11.8601
R933 VDD.n310 VDD.n38 11.3205
R934 VDD.n392 VDD.n391 11.3205
R935 VDD.n482 VDD.n481 11.3205
R936 VDD.n495 VDD.n494 11.3205
R937 VDD.n320 VDD.n249 10.5417
R938 VDD.n255 VDD.n250 10.5417
R939 VDD.n244 VDD.n243 10.5417
R940 VDD.n205 VDD.n163 10.5417
R941 VDD.n94 VDD.n90 10.5417
R942 VDD.n85 VDD.n84 10.5417
R943 VDD.n251 VDD.n248 10.5417
R944 VDD.n321 VDD.n319 10.5417
R945 VDD.n414 VDD.n394 10.5417
R946 VDD.n405 VDD.n404 10.5417
R947 VDD.n368 VDD.n271 10.1652
R948 VDD.n230 VDD.n229 10.1652
R949 VDD.n190 VDD.n189 10.1652
R950 VDD.n112 VDD.n111 10.1652
R951 VDD.n66 VDD.n65 10.1652
R952 VDD.n269 VDD.n267 10.1652
R953 VDD.n300 VDD.n299 10.1652
R954 VDD.n432 VDD.n431 10.1652
R955 VDD.n17 VDD.n5 10.1652
R956 VDD.n380 VDD.n256 9.41227
R957 VDD.n363 VDD.n276 9.41227
R958 VDD.n236 VDD.n235 9.41227
R959 VDD.n199 VDD.n165 9.41227
R960 VDD.n184 VDD.n183 9.41227
R961 VDD.n104 VDD.n103 9.41227
R962 VDD.n76 VDD.n75 9.41227
R963 VDD.n60 VDD.n59 9.41227
R964 VDD.n264 VDD.n260 9.41227
R965 VDD.n316 VDD.n315 9.41227
R966 VDD.n291 VDD.n288 9.41227
R967 VDD.n424 VDD.n423 9.41227
R968 VDD.n399 VDD.n36 9.41227
R969 VDD.n25 VDD.n4 9.41227
R970 VDD.n177 VDD 9.3031
R971 VDD.n53 VDD 9.3031
R972 VDD.n353 VDD 9.3031
R973 VDD.n32 VDD 9.3031
R974 VDD.n178 VDD.n176 9.3005
R975 VDD.n180 VDD.n179 9.3005
R976 VDD.n182 VDD.n181 9.3005
R977 VDD.n183 VDD.n173 9.3005
R978 VDD.n186 VDD.n185 9.3005
R979 VDD.n187 VDD.n172 9.3005
R980 VDD.n189 VDD.n188 9.3005
R981 VDD.n190 VDD.n170 9.3005
R982 VDD.n191 VDD.n169 9.3005
R983 VDD.n193 VDD.n192 9.3005
R984 VDD.n194 VDD.n168 9.3005
R985 VDD.n196 VDD.n195 9.3005
R986 VDD.n198 VDD.n166 9.3005
R987 VDD.n200 VDD.n199 9.3005
R988 VDD.n203 VDD.n202 9.3005
R989 VDD.n204 VDD.n164 9.3005
R990 VDD.n206 VDD.n205 9.3005
R991 VDD.n208 VDD.n207 9.3005
R992 VDD.n209 VDD.n161 9.3005
R993 VDD.n245 VDD.n244 9.3005
R994 VDD.n242 VDD.n162 9.3005
R995 VDD.n241 VDD.n240 9.3005
R996 VDD.n239 VDD.n210 9.3005
R997 VDD.n238 VDD.n237 9.3005
R998 VDD.n236 VDD.n211 9.3005
R999 VDD.n234 VDD.n233 9.3005
R1000 VDD.n232 VDD.n214 9.3005
R1001 VDD.n231 VDD.n230 9.3005
R1002 VDD.n229 VDD.n215 9.3005
R1003 VDD.n227 VDD.n226 9.3005
R1004 VDD.n225 VDD.n216 9.3005
R1005 VDD.n224 VDD.n223 9.3005
R1006 VDD.n222 VDD.n217 9.3005
R1007 VDD.n221 VDD.n220 9.3005
R1008 VDD.n54 VDD.n52 9.3005
R1009 VDD.n56 VDD.n55 9.3005
R1010 VDD.n58 VDD.n57 9.3005
R1011 VDD.n59 VDD.n49 9.3005
R1012 VDD.n62 VDD.n61 9.3005
R1013 VDD.n63 VDD.n48 9.3005
R1014 VDD.n65 VDD.n64 9.3005
R1015 VDD.n66 VDD.n46 9.3005
R1016 VDD.n67 VDD.n45 9.3005
R1017 VDD.n69 VDD.n68 9.3005
R1018 VDD.n70 VDD.n44 9.3005
R1019 VDD.n73 VDD.n72 9.3005
R1020 VDD.n78 VDD.n77 9.3005
R1021 VDD.n76 VDD.n39 9.3005
R1022 VDD.n492 VDD.n40 9.3005
R1023 VDD.n489 VDD.n83 9.3005
R1024 VDD.n488 VDD.n84 9.3005
R1025 VDD.n487 VDD.n86 9.3005
R1026 VDD.n484 VDD.n89 9.3005
R1027 VDD.n160 VDD.n90 9.3005
R1028 VDD.n95 VDD.n91 9.3005
R1029 VDD.n156 VDD.n96 9.3005
R1030 VDD.n155 VDD.n97 9.3005
R1031 VDD.n102 VDD.n98 9.3005
R1032 VDD.n151 VDD.n103 9.3005
R1033 VDD.n150 VDD.n105 9.3005
R1034 VDD.n149 VDD.n106 9.3005
R1035 VDD.n111 VDD.n107 9.3005
R1036 VDD.n144 VDD.n112 9.3005
R1037 VDD.n143 VDD.n113 9.3005
R1038 VDD.n142 VDD.n114 9.3005
R1039 VDD.n138 VDD.n117 9.3005
R1040 VDD.n137 VDD.n118 9.3005
R1041 VDD.n136 VDD.n119 9.3005
R1042 VDD.n133 VDD.n121 9.3005
R1043 VDD.n132 VDD.n122 9.3005
R1044 VDD.n131 VDD.n123 9.3005
R1045 VDD.n128 VDD.n124 9.3005
R1046 VDD.n131 VDD.n130 9.3005
R1047 VDD.n132 VDD.n120 9.3005
R1048 VDD.n134 VDD.n133 9.3005
R1049 VDD.n136 VDD.n135 9.3005
R1050 VDD.n137 VDD.n116 9.3005
R1051 VDD.n139 VDD.n138 9.3005
R1052 VDD.n142 VDD.n141 9.3005
R1053 VDD.n143 VDD.n109 9.3005
R1054 VDD.n145 VDD.n144 9.3005
R1055 VDD.n147 VDD.n107 9.3005
R1056 VDD.n149 VDD.n148 9.3005
R1057 VDD.n150 VDD.n99 9.3005
R1058 VDD.n152 VDD.n151 9.3005
R1059 VDD.n153 VDD.n98 9.3005
R1060 VDD.n155 VDD.n154 9.3005
R1061 VDD.n157 VDD.n156 9.3005
R1062 VDD.n158 VDD.n91 9.3005
R1063 VDD.n160 VDD.n159 9.3005
R1064 VDD.n485 VDD.n484 9.3005
R1065 VDD.n487 VDD.n486 9.3005
R1066 VDD.n488 VDD.n82 9.3005
R1067 VDD.n490 VDD.n489 9.3005
R1068 VDD.n492 VDD.n491 9.3005
R1069 VDD.n81 VDD.n39 9.3005
R1070 VDD.n79 VDD.n78 9.3005
R1071 VDD.n72 VDD.n42 9.3005
R1072 VDD.n352 VDD.n286 9.3005
R1073 VDD.n351 VDD.n350 9.3005
R1074 VDD.n347 VDD.n346 9.3005
R1075 VDD.n343 VDD.n288 9.3005
R1076 VDD.n342 VDD.n292 9.3005
R1077 VDD.n341 VDD.n293 9.3005
R1078 VDD.n299 VDD.n294 9.3005
R1079 VDD.n300 VDD.n296 9.3005
R1080 VDD.n336 VDD.n301 9.3005
R1081 VDD.n335 VDD.n302 9.3005
R1082 VDD.n334 VDD.n303 9.3005
R1083 VDD.n312 VDD.n304 9.3005
R1084 VDD.n314 VDD.n307 9.3005
R1085 VDD.n315 VDD.n306 9.3005
R1086 VDD.n329 VDD.n317 9.3005
R1087 VDD.n328 VDD.n318 9.3005
R1088 VDD.n327 VDD.n319 9.3005
R1089 VDD.n324 VDD.n323 9.3005
R1090 VDD.n322 VDD.n247 9.3005
R1091 VDD.n390 VDD.n248 9.3005
R1092 VDD.n387 VDD.n252 9.3005
R1093 VDD.n386 VDD.n253 9.3005
R1094 VDD.n385 VDD.n254 9.3005
R1095 VDD.n382 VDD.n259 9.3005
R1096 VDD.n381 VDD.n260 9.3005
R1097 VDD.n265 VDD.n261 9.3005
R1098 VDD.n376 VDD.n266 9.3005
R1099 VDD.n375 VDD.n267 9.3005
R1100 VDD.n374 VDD.n269 9.3005
R1101 VDD.n371 VDD.n272 9.3005
R1102 VDD.n370 VDD.n273 9.3005
R1103 VDD.n369 VDD.n274 9.3005
R1104 VDD.n277 VDD.n275 9.3005
R1105 VDD.n365 VDD.n278 9.3005
R1106 VDD.n364 VDD.n279 9.3005
R1107 VDD.n283 VDD.n280 9.3005
R1108 VDD.n359 VDD.n284 9.3005
R1109 VDD.n358 VDD.n285 9.3005
R1110 VDD.n357 VDD.n356 9.3005
R1111 VDD.n346 VDD.n345 9.3005
R1112 VDD.n344 VDD.n343 9.3005
R1113 VDD.n342 VDD.n290 9.3005
R1114 VDD.n341 VDD.n340 9.3005
R1115 VDD.n339 VDD.n294 9.3005
R1116 VDD.n338 VDD.n296 9.3005
R1117 VDD.n337 VDD.n336 9.3005
R1118 VDD.n335 VDD.n297 9.3005
R1119 VDD.n334 VDD.n333 9.3005
R1120 VDD.n332 VDD.n304 9.3005
R1121 VDD.n331 VDD.n307 9.3005
R1122 VDD.n331 VDD.n306 9.3005
R1123 VDD.n330 VDD.n329 9.3005
R1124 VDD.n328 VDD.n309 9.3005
R1125 VDD.n327 VDD.n326 9.3005
R1126 VDD.n325 VDD.n324 9.3005
R1127 VDD.n249 VDD.n247 9.3005
R1128 VDD.n390 VDD.n389 9.3005
R1129 VDD.n388 VDD.n387 9.3005
R1130 VDD.n386 VDD.n250 9.3005
R1131 VDD.n385 VDD.n384 9.3005
R1132 VDD.n383 VDD.n382 9.3005
R1133 VDD.n381 VDD.n380 9.3005
R1134 VDD.n379 VDD.n261 9.3005
R1135 VDD.n377 VDD.n376 9.3005
R1136 VDD.n375 VDD.n263 9.3005
R1137 VDD.n374 VDD.n373 9.3005
R1138 VDD.n372 VDD.n371 9.3005
R1139 VDD.n370 VDD.n271 9.3005
R1140 VDD.n369 VDD.n368 9.3005
R1141 VDD.n367 VDD.n275 9.3005
R1142 VDD.n366 VDD.n365 9.3005
R1143 VDD.n364 VDD.n363 9.3005
R1144 VDD.n362 VDD.n280 9.3005
R1145 VDD.n360 VDD.n359 9.3005
R1146 VDD.n358 VDD.n282 9.3005
R1147 VDD.n31 VDD.n2 9.3005
R1148 VDD.n30 VDD.n29 9.3005
R1149 VDD.n26 VDD.n3 9.3005
R1150 VDD.n25 VDD.n24 9.3005
R1151 VDD.n23 VDD.n22 9.3005
R1152 VDD.n21 VDD.n20 9.3005
R1153 VDD.n19 VDD.n5 9.3005
R1154 VDD.n18 VDD.n17 9.3005
R1155 VDD.n15 VDD.n6 9.3005
R1156 VDD.n14 VDD.n13 9.3005
R1157 VDD.n12 VDD.n10 9.3005
R1158 VDD.n9 VDD.n0 9.3005
R1159 VDD.n500 VDD.n1 9.3005
R1160 VDD.n496 VDD.n36 9.3005
R1161 VDD.n400 VDD.n37 9.3005
R1162 VDD.n403 VDD.n402 9.3005
R1163 VDD.n404 VDD.n398 9.3005
R1164 VDD.n408 VDD.n407 9.3005
R1165 VDD.n406 VDD.n393 9.3005
R1166 VDD.n480 VDD.n394 9.3005
R1167 VDD.n415 VDD.n395 9.3005
R1168 VDD.n476 VDD.n416 9.3005
R1169 VDD.n475 VDD.n417 9.3005
R1170 VDD.n422 VDD.n418 9.3005
R1171 VDD.n471 VDD.n423 9.3005
R1172 VDD.n470 VDD.n425 9.3005
R1173 VDD.n469 VDD.n426 9.3005
R1174 VDD.n431 VDD.n427 9.3005
R1175 VDD.n464 VDD.n432 9.3005
R1176 VDD.n463 VDD.n433 9.3005
R1177 VDD.n462 VDD.n434 9.3005
R1178 VDD.n458 VDD.n437 9.3005
R1179 VDD.n457 VDD.n438 9.3005
R1180 VDD.n456 VDD.n439 9.3005
R1181 VDD.n453 VDD.n441 9.3005
R1182 VDD.n452 VDD.n442 9.3005
R1183 VDD.n451 VDD.n443 9.3005
R1184 VDD.n448 VDD.n444 9.3005
R1185 VDD.n451 VDD.n450 9.3005
R1186 VDD.n452 VDD.n440 9.3005
R1187 VDD.n454 VDD.n453 9.3005
R1188 VDD.n456 VDD.n455 9.3005
R1189 VDD.n457 VDD.n436 9.3005
R1190 VDD.n459 VDD.n458 9.3005
R1191 VDD.n462 VDD.n461 9.3005
R1192 VDD.n463 VDD.n429 9.3005
R1193 VDD.n465 VDD.n464 9.3005
R1194 VDD.n467 VDD.n427 9.3005
R1195 VDD.n469 VDD.n468 9.3005
R1196 VDD.n470 VDD.n419 9.3005
R1197 VDD.n472 VDD.n471 9.3005
R1198 VDD.n473 VDD.n418 9.3005
R1199 VDD.n475 VDD.n474 9.3005
R1200 VDD.n477 VDD.n476 9.3005
R1201 VDD.n478 VDD.n395 9.3005
R1202 VDD.n480 VDD.n479 9.3005
R1203 VDD.n410 VDD.n393 9.3005
R1204 VDD.n409 VDD.n408 9.3005
R1205 VDD.n398 VDD.n397 9.3005
R1206 VDD.n402 VDD.n401 9.3005
R1207 VDD.n37 VDD.n35 9.3005
R1208 VDD.n497 VDD.n496 9.3005
R1209 VDD.n500 VDD.n499 9.3005
R1210 VDD.n33 VDD.n0 9.3005
R1211 VDD.t172 VDD 8.61077
R1212 VDD.t177 VDD.t50 8.61077
R1213 VDD.n325 VDD.n320 8.28285
R1214 VDD.n384 VDD.n255 8.28285
R1215 VDD.n243 VDD.n242 8.28285
R1216 VDD.n208 VDD.n163 8.28285
R1217 VDD.n95 VDD.n94 8.28285
R1218 VDD.n86 VDD.n85 8.28285
R1219 VDD.n252 VDD.n251 8.28285
R1220 VDD.n323 VDD.n321 8.28285
R1221 VDD.n415 VDD.n414 8.28285
R1222 VDD.n407 VDD.n405 8.28285
R1223 VDD.n219 VDD.n218 7.25905
R1224 VDD.t207 VDD.t234 7.17573
R1225 VDD.t201 VDD.t254 7.17573
R1226 VDD.n379 VDD.n378 6.4005
R1227 VDD.n362 VDD.n361 6.4005
R1228 VDD.n237 VDD.n213 6.4005
R1229 VDD.n198 VDD.n197 6.4005
R1230 VDD.n182 VDD.n175 6.4005
R1231 VDD.n102 VDD.n101 6.4005
R1232 VDD.n77 VDD.n74 6.4005
R1233 VDD.n58 VDD.n51 6.4005
R1234 VDD.n259 VDD.n258 6.4005
R1235 VDD.n314 VDD.n313 6.4005
R1236 VDD.n349 VDD.n347 6.4005
R1237 VDD.n422 VDD.n421 6.4005
R1238 VDD.n8 VDD.n1 6.4005
R1239 VDD.n28 VDD.n26 6.4005
R1240 VDD.n354 VDD.t8 5.75555
R1241 VDD.t166 VDD 4.30564
R1242 VDD.t15 VDD 4.30564
R1243 VDD.n383 VDD.n256 4.14168
R1244 VDD.n366 VDD.n276 4.14168
R1245 VDD.n235 VDD.n234 4.14168
R1246 VDD.n203 VDD.n165 4.14168
R1247 VDD.n185 VDD.n184 4.14168
R1248 VDD.n105 VDD.n104 4.14168
R1249 VDD.n75 VDD.n40 4.14168
R1250 VDD.n61 VDD.n60 4.14168
R1251 VDD.n265 VDD.n264 4.14168
R1252 VDD.n317 VDD.n316 4.14168
R1253 VDD.n292 VDD.n291 4.14168
R1254 VDD.n425 VDD.n424 4.14168
R1255 VDD.n400 VDD.n399 4.14168
R1256 VDD.n22 VDD.n4 4.14168
R1257 VDD.n378 VDD.n377 3.38874
R1258 VDD.n361 VDD.n360 3.38874
R1259 VDD.n213 VDD.n210 3.38874
R1260 VDD.n197 VDD.n196 3.38874
R1261 VDD.n179 VDD.n175 3.38874
R1262 VDD.n101 VDD.n97 3.38874
R1263 VDD.n74 VDD.n73 3.38874
R1264 VDD.n55 VDD.n51 3.38874
R1265 VDD.n258 VDD.n254 3.38874
R1266 VDD.n313 VDD.n312 3.38874
R1267 VDD.n350 VDD.n349 3.38874
R1268 VDD.n421 VDD.n417 3.38874
R1269 VDD.n9 VDD.n8 3.38874
R1270 VDD.n29 VDD.n28 3.38874
R1271 VDD.t232 VDD.t193 1.43555
R1272 VDD VDD.t89 1.43555
R1273 VDD VDD.t178 1.43555
R1274 VDD VDD.t82 1.43555
R1275 VDD.t258 VDD.t187 1.43555
R1276 VDD.n81 VDD.n80 0.753441
R1277 VDD.n154 VDD.n93 0.753441
R1278 VDD.n140 VDD.n139 0.753441
R1279 VDD.n498 VDD.n497 0.753441
R1280 VDD.n474 VDD.n413 0.753441
R1281 VDD.n460 VDD.n459 0.753441
R1282 VDD.n494 VDD.n38 0.550574
R1283 VDD.n482 VDD.n392 0.549704
R1284 VDD.n71 VDD 0.479667
R1285 VDD.n11 VDD 0.479667
R1286 VDD.n219 VDD 0.47207
R1287 VDD.n287 VDD 0.359875
R1288 VDD.n180 VDD.n176 0.120292
R1289 VDD.n181 VDD.n180 0.120292
R1290 VDD.n181 VDD.n173 0.120292
R1291 VDD.n186 VDD.n173 0.120292
R1292 VDD.n188 VDD.n187 0.120292
R1293 VDD.n188 VDD.n170 0.120292
R1294 VDD.n170 VDD.n169 0.120292
R1295 VDD.n193 VDD.n169 0.120292
R1296 VDD.n195 VDD.n194 0.120292
R1297 VDD.n195 VDD.n166 0.120292
R1298 VDD.n200 VDD.n166 0.120292
R1299 VDD.n206 VDD.n164 0.120292
R1300 VDD.n207 VDD.n206 0.120292
R1301 VDD.n245 VDD.n162 0.120292
R1302 VDD.n240 VDD.n239 0.120292
R1303 VDD.n239 VDD.n238 0.120292
R1304 VDD.n238 VDD.n211 0.120292
R1305 VDD.n233 VDD.n211 0.120292
R1306 VDD.n232 VDD.n231 0.120292
R1307 VDD.n231 VDD.n215 0.120292
R1308 VDD.n226 VDD.n215 0.120292
R1309 VDD.n226 VDD.n225 0.120292
R1310 VDD.n224 VDD.n217 0.120292
R1311 VDD.n220 VDD.n217 0.120292
R1312 VDD.n56 VDD.n52 0.120292
R1313 VDD.n57 VDD.n56 0.120292
R1314 VDD.n57 VDD.n49 0.120292
R1315 VDD.n62 VDD.n49 0.120292
R1316 VDD.n64 VDD.n63 0.120292
R1317 VDD.n64 VDD.n46 0.120292
R1318 VDD.n46 VDD.n45 0.120292
R1319 VDD.n69 VDD.n45 0.120292
R1320 VDD.n352 VDD.n351 0.120292
R1321 VDD.n31 VDD.n30 0.120292
R1322 VDD.n30 VDD.n3 0.120292
R1323 VDD.n24 VDD.n3 0.120292
R1324 VDD.n24 VDD.n23 0.120292
R1325 VDD.n20 VDD.n19 0.120292
R1326 VDD.n19 VDD.n18 0.120292
R1327 VDD.n18 VDD.n6 0.120292
R1328 VDD.n13 VDD.n6 0.120292
R1329 VDD.n246 VDD.n161 0.117688
R1330 VDD.n202 VDD.n201 0.115083
R1331 VDD VDD.n219 0.0925638
R1332 VDD VDD.n176 0.0603958
R1333 VDD.n187 VDD 0.0603958
R1334 VDD.n194 VDD 0.0603958
R1335 VDD VDD.n164 0.0603958
R1336 VDD VDD.n161 0.0603958
R1337 VDD.n240 VDD 0.0603958
R1338 VDD VDD.n232 0.0603958
R1339 VDD VDD.n224 0.0603958
R1340 VDD VDD.n52 0.0603958
R1341 VDD.n63 VDD 0.0603958
R1342 VDD.n70 VDD 0.0603958
R1343 VDD.n71 VDD.n70 0.0603958
R1344 VDD.n489 VDD.n488 0.0603958
R1345 VDD.n488 VDD.n487 0.0603958
R1346 VDD.n160 VDD.n91 0.0603958
R1347 VDD.n155 VDD.n98 0.0603958
R1348 VDD.n151 VDD.n98 0.0603958
R1349 VDD.n151 VDD.n150 0.0603958
R1350 VDD.n149 VDD.n107 0.0603958
R1351 VDD.n144 VDD.n107 0.0603958
R1352 VDD.n144 VDD.n143 0.0603958
R1353 VDD.n138 VDD.n137 0.0603958
R1354 VDD.n137 VDD.n136 0.0603958
R1355 VDD.n133 VDD.n132 0.0603958
R1356 VDD.n132 VDD.n131 0.0603958
R1357 VDD.n131 VDD.n124 0.0603958
R1358 VDD VDD.n352 0.0603958
R1359 VDD.n351 VDD.n287 0.0603958
R1360 VDD.n343 VDD.n342 0.0603958
R1361 VDD.n341 VDD.n294 0.0603958
R1362 VDD.n296 VDD.n294 0.0603958
R1363 VDD.n336 VDD.n296 0.0603958
R1364 VDD.n334 VDD.n304 0.0603958
R1365 VDD.n328 VDD.n327 0.0603958
R1366 VDD.n386 VDD.n385 0.0603958
R1367 VDD.n381 VDD.n261 0.0603958
R1368 VDD.n376 VDD.n375 0.0603958
R1369 VDD.n371 VDD.n370 0.0603958
R1370 VDD.n369 VDD.n275 0.0603958
R1371 VDD.n364 VDD.n280 0.0603958
R1372 VDD.n359 VDD.n280 0.0603958
R1373 VDD.n359 VDD.n358 0.0603958
R1374 VDD VDD.n31 0.0603958
R1375 VDD.n20 VDD 0.0603958
R1376 VDD VDD.n12 0.0603958
R1377 VDD.n12 VDD.n11 0.0603958
R1378 VDD.n402 VDD.n398 0.0603958
R1379 VDD.n408 VDD.n398 0.0603958
R1380 VDD.n480 VDD.n395 0.0603958
R1381 VDD.n475 VDD.n418 0.0603958
R1382 VDD.n471 VDD.n418 0.0603958
R1383 VDD.n471 VDD.n470 0.0603958
R1384 VDD.n469 VDD.n427 0.0603958
R1385 VDD.n464 VDD.n427 0.0603958
R1386 VDD.n464 VDD.n463 0.0603958
R1387 VDD.n458 VDD.n457 0.0603958
R1388 VDD.n457 VDD.n456 0.0603958
R1389 VDD.n453 VDD.n452 0.0603958
R1390 VDD.n452 VDD.n451 0.0603958
R1391 VDD.n451 VDD.n444 0.0603958
R1392 VDD.n484 VDD.n483 0.0590938
R1393 VDD.n391 VDD.n247 0.0590938
R1394 VDD.n481 VDD.n393 0.0590938
R1395 VDD.n329 VDD.n310 0.0577917
R1396 VDD.n495 VDD.n37 0.0577917
R1397 VDD.n493 VDD.n492 0.0564896
R1398 VDD.n127 VDD.n126 0.0503767
R1399 VDD.n447 VDD.n446 0.0503767
R1400 VDD.n343 VDD 0.0493281
R1401 VDD VDD.n306 0.0493281
R1402 VDD VDD.n381 0.0493281
R1403 VDD.n371 VDD 0.0493281
R1404 VDD VDD.n39 0.0486771
R1405 VDD VDD.n155 0.0486771
R1406 VDD.n496 VDD 0.0486771
R1407 VDD VDD.n475 0.0486771
R1408 VDD.n72 VDD.n71 0.0304479
R1409 VDD.n78 VDD 0.0304479
R1410 VDD.n489 VDD 0.0304479
R1411 VDD.n484 VDD 0.0304479
R1412 VDD.n156 VDD 0.0304479
R1413 VDD VDD.n149 0.0304479
R1414 VDD.n143 VDD 0.0304479
R1415 VDD VDD.n142 0.0304479
R1416 VDD.n138 VDD 0.0304479
R1417 VDD.n133 VDD 0.0304479
R1418 VDD.n346 VDD.n287 0.0304479
R1419 VDD VDD.n341 0.0304479
R1420 VDD.n336 VDD 0.0304479
R1421 VDD VDD.n335 0.0304479
R1422 VDD VDD.n334 0.0304479
R1423 VDD VDD.n304 0.0304479
R1424 VDD.n307 VDD 0.0304479
R1425 VDD VDD.n328 0.0304479
R1426 VDD.n327 VDD 0.0304479
R1427 VDD.n324 VDD 0.0304479
R1428 VDD VDD.n247 0.0304479
R1429 VDD.n390 VDD 0.0304479
R1430 VDD.n387 VDD 0.0304479
R1431 VDD VDD.n386 0.0304479
R1432 VDD.n382 VDD 0.0304479
R1433 VDD.n376 VDD 0.0304479
R1434 VDD.n375 VDD 0.0304479
R1435 VDD VDD.n374 0.0304479
R1436 VDD VDD.n369 0.0304479
R1437 VDD VDD.n275 0.0304479
R1438 VDD.n365 VDD 0.0304479
R1439 VDD VDD.n364 0.0304479
R1440 VDD.n358 VDD 0.0304479
R1441 VDD VDD.n357 0.0304479
R1442 VDD.n11 VDD.n0 0.0304479
R1443 VDD VDD.n500 0.0304479
R1444 VDD.n402 VDD 0.0304479
R1445 VDD VDD.n393 0.0304479
R1446 VDD.n476 VDD 0.0304479
R1447 VDD VDD.n469 0.0304479
R1448 VDD.n463 VDD 0.0304479
R1449 VDD VDD.n462 0.0304479
R1450 VDD.n458 VDD 0.0304479
R1451 VDD.n453 VDD 0.0304479
R1452 VDD VDD.n186 0.0226354
R1453 VDD VDD.n193 0.0226354
R1454 VDD.n202 VDD 0.0226354
R1455 VDD.n207 VDD 0.0226354
R1456 VDD VDD.n162 0.0226354
R1457 VDD.n233 VDD 0.0226354
R1458 VDD.n225 VDD 0.0226354
R1459 VDD VDD.n62 0.0226354
R1460 VDD VDD.n69 0.0226354
R1461 VDD.n23 VDD 0.0226354
R1462 VDD.n13 VDD 0.0226354
R1463 VDD.n220 VDD 0.0213333
R1464 VDD.n78 VDD 0.0122188
R1465 VDD.n156 VDD 0.0122188
R1466 VDD.n500 VDD 0.0122188
R1467 VDD.n476 VDD 0.0122188
R1468 VDD.n492 VDD 0.0115677
R1469 VDD.n487 VDD 0.0115677
R1470 VDD VDD.n91 0.0115677
R1471 VDD.n150 VDD 0.0115677
R1472 VDD.n142 VDD 0.0115677
R1473 VDD.n127 VDD 0.0115677
R1474 VDD.n342 VDD 0.0115677
R1475 VDD.n307 VDD 0.0115677
R1476 VDD.n329 VDD 0.0115677
R1477 VDD.n324 VDD 0.0115677
R1478 VDD.n387 VDD 0.0115677
R1479 VDD.n385 VDD 0.0115677
R1480 VDD.n382 VDD 0.0115677
R1481 VDD VDD.n261 0.0115677
R1482 VDD.n374 VDD 0.0115677
R1483 VDD.n370 VDD 0.0115677
R1484 VDD.n357 VDD 0.0115677
R1485 VDD VDD.n37 0.0115677
R1486 VDD.n408 VDD 0.0115677
R1487 VDD VDD.n395 0.0115677
R1488 VDD.n470 VDD 0.0115677
R1489 VDD.n462 VDD 0.0115677
R1490 VDD.n447 VDD 0.0115677
R1491 VDD.n126 VDD.n124 0.0114518
R1492 VDD.n446 VDD.n444 0.0114518
R1493 VDD.n136 VDD 0.0109167
R1494 VDD.n335 VDD 0.0109167
R1495 VDD.n365 VDD 0.0109167
R1496 VDD.n456 VDD 0.0109167
R1497 VDD.n201 VDD.n200 0.00570833
R1498 VDD.n493 VDD.n39 0.00440625
R1499 VDD.n246 VDD.n245 0.00310417
R1500 VDD.n310 VDD.n306 0.00310417
R1501 VDD.n496 VDD.n495 0.00310417
R1502 VDD.n72 VDD 0.00180208
R1503 VDD.n483 VDD.n160 0.00180208
R1504 VDD.n346 VDD 0.00180208
R1505 VDD.n391 VDD.n390 0.00180208
R1506 VDD VDD.n0 0.00180208
R1507 VDD.n481 VDD.n480 0.00180208
R1508 GND.n213 GND.n42 1.1936e+06
R1509 GND.n332 GND 15402.8
R1510 GND.n330 GND.n42 12888.5
R1511 GND.n332 GND.n330 12888.5
R1512 GND.n331 GND.n41 8568.96
R1513 GND.n213 GND.n212 8502.07
R1514 GND.n212 GND.n41 5649.6
R1515 GND.t107 GND 2584.13
R1516 GND.t154 GND 2584.13
R1517 GND.t105 GND.n331 2570.16
R1518 GND.t236 GND 2374.6
R1519 GND.t228 GND 2374.6
R1520 GND.t109 GND 2332.7
R1521 GND.t152 GND 2332.7
R1522 GND.t230 GND 1773.97
R1523 GND.t226 GND 1732.06
R1524 GND.t126 GND.t105 1508.57
R1525 GND.t252 GND.t109 1508.57
R1526 GND.t111 GND.t152 1508.57
R1527 GND GND.t236 1480.63
R1528 GND GND.t228 1480.63
R1529 GND.t250 GND.t232 1438.73
R1530 GND GND.t104 1410.79
R1531 GND GND.t169 1410.79
R1532 GND GND.t113 1410.79
R1533 GND.t114 GND.t107 1354.92
R1534 GND.t234 GND.t154 1354.92
R1535 GND GND.t266 1313.02
R1536 GND GND.t254 1313.02
R1537 GND.t25 GND.n268 1310.03
R1538 GND GND.n42 1281.55
R1539 GND.n330 GND 1281.55
R1540 GND GND.n332 1281.55
R1541 GND.t128 GND.n31 1198.25
R1542 GND.t12 GND.n329 1198.25
R1543 GND.n211 GND.n210 1198.25
R1544 GND.n334 GND.n333 1198.25
R1545 GND.n268 GND.n267 1198.25
R1546 GND.n270 GND.n269 1198.25
R1547 GND.n331 GND.n0 1198.25
R1548 GND.t232 GND.t262 1187.3
R1549 GND.t188 GND 1174.76
R1550 GND GND.t194 1174.76
R1551 GND.t104 GND.t126 1173.33
R1552 GND.t266 GND.t114 1173.33
R1553 GND.t169 GND.t252 1173.33
R1554 GND.t113 GND.t111 1173.33
R1555 GND.t254 GND.t234 1173.33
R1556 GND.t264 GND.t230 1173.33
R1557 GND.t262 GND.t226 1173.33
R1558 GND.t12 GND 978.872
R1559 GND GND.t128 978.872
R1560 GND.n212 GND.n211 958.917
R1561 GND.n333 GND.n41 958.917
R1562 GND GND.t250 907.938
R1563 GND GND.t264 893.968
R1564 GND.t83 GND 875.729
R1565 GND GND.t6 875.729
R1566 GND GND.t0 848.802
R1567 GND GND.t145 848.802
R1568 GND.t52 GND 847.25
R1569 GND.n211 GND.t8 844.213
R1570 GND.n333 GND.t2 844.213
R1571 GND.t160 GND.t14 840.13
R1572 GND.t151 GND.t218 840.13
R1573 GND.t17 GND.t122 783.173
R1574 GND.t41 GND.t25 768.933
R1575 GND.t120 GND.t19 768.933
R1576 GND.t166 GND.t12 768.933
R1577 GND.t128 GND.t202 768.933
R1578 GND GND.t140 754.693
R1579 GND GND.t242 754.693
R1580 GND GND.t212 754.693
R1581 GND.t256 GND 754.693
R1582 GND.t118 GND.t138 733.333
R1583 GND.t242 GND.t54 697.736
R1584 GND.t29 GND.t27 690.615
R1585 GND.t62 GND.t49 683.495
R1586 GND.t81 GND.t93 683.495
R1587 GND.t68 GND.t87 683.495
R1588 GND.t168 GND.t186 683.495
R1589 GND.t134 GND.t96 683.495
R1590 GND.t86 GND.t73 669.256
R1591 GND GND.t164 669.256
R1592 GND.t144 GND.t11 669.256
R1593 GND.t206 GND 669.256
R1594 GND GND.t200 662.136
R1595 GND.t34 GND 647.896
R1596 GND GND.t17 647.896
R1597 GND.t15 GND.t58 633.658
R1598 GND.t87 GND 633.658
R1599 GND GND.t134 633.658
R1600 GND.t33 GND 612.298
R1601 GND GND.t40 612.298
R1602 GND.t156 GND.t246 605.178
R1603 GND.t220 GND.t214 605.178
R1604 GND.t48 GND.t60 598.058
R1605 GND.t196 GND.t238 598.058
R1606 GND.t164 GND.t158 598.058
R1607 GND.t216 GND.t206 598.058
R1608 GND.t58 GND 555.341
R1609 GND.t122 GND 533.981
R1610 GND.t50 GND.t56 512.621
R1611 GND.t54 GND 512.621
R1612 GND.t176 GND.t68 512.621
R1613 GND.t210 GND 512.621
R1614 GND.t96 GND.t178 512.621
R1615 GND GND.t260 512.621
R1616 GND.n268 GND.n213 505.502
R1617 GND.t248 GND.t174 505.502
R1618 GND.t182 GND.t222 505.502
R1619 GND.t238 GND.t38 498.382
R1620 GND.t8 GND.t76 495.517
R1621 GND.t2 GND.t131 495.517
R1622 GND.t64 GND.t21 484.142
R1623 GND.t47 GND 477.024
R1624 GND.t22 GND 477.024
R1625 GND.t74 GND 463.399
R1626 GND.t10 GND 463.399
R1627 GND GND.t57 462.784
R1628 GND.t172 GND.t142 462.784
R1629 GND GND.t162 462.784
R1630 GND.t98 GND.t184 462.784
R1631 GND.t204 GND 462.784
R1632 GND GND.t196 455.663
R1633 GND.t200 GND.t45 448.545
R1634 GND.t0 GND.t78 445.048
R1635 GND.t145 GND.t100 445.048
R1636 GND.t244 GND 431.284
R1637 GND.t224 GND 431.284
R1638 GND.t91 GND.t208 412.945
R1639 GND.t258 GND.t147 412.945
R1640 GND.t38 GND 405.825
R1641 GND.t192 GND.t80 405.825
R1642 GND.t170 GND.t156 405.825
R1643 GND.t130 GND.t190 405.825
R1644 GND.t214 GND.t180 405.825
R1645 GND.t240 GND.t22 398.707
R1646 GND.t198 GND.t124 398.707
R1647 GND.t76 GND.t74 385.401
R1648 GND.t78 GND.t244 385.401
R1649 GND.t131 GND.t10 385.401
R1650 GND.t100 GND.t224 385.401
R1651 GND.t43 GND.t136 384.466
R1652 GND.t36 GND.t116 384.466
R1653 GND.t85 GND.t71 377.346
R1654 GND.t4 GND.t133 377.346
R1655 GND.t32 GND.t24 370.228
R1656 GND.t31 GND.t23 370.228
R1657 GND.t66 GND.t198 370.228
R1658 GND.t14 GND 370.228
R1659 GND GND.t151 370.228
R1660 GND.t140 GND.t52 363.108
R1661 GND.t27 GND.t62 341.748
R1662 GND.t19 GND.t48 341.748
R1663 GND.n269 GND.t118 341.748
R1664 GND.t162 GND.t170 327.509
R1665 GND.t180 GND.t204 327.509
R1666 GND GND.t192 313.269
R1667 GND.t190 GND 313.269
R1668 GND.t71 GND.t172 306.149
R1669 GND.t184 GND.t4 306.149
R1670 GND.t49 GND 291.909
R1671 GND GND.t36 284.791
R1672 GND.n98 GND.t163 282.663
R1673 GND.n420 GND.t205 282.663
R1674 GND.n272 GND.t119 282.663
R1675 GND.n462 GND.t251 282.663
R1676 GND.n105 GND.t209 278.589
R1677 GND.n427 GND.t259 278.589
R1678 GND.n279 GND.t241 278.589
R1679 GND.n468 GND.t227 278.589
R1680 GND GND.t70 277.671
R1681 GND.t75 GND 277.671
R1682 GND.t208 GND.t33 270.55
R1683 GND.t40 GND.t258 270.55
R1684 GND.t57 GND.t32 256.312
R1685 GND.t60 GND 249.191
R1686 GND.n167 GND.t44 246.506
R1687 GND.n74 GND.t165 246.506
R1688 GND.n190 GND.t245 246.506
R1689 GND.n396 GND.t207 246.506
R1690 GND.n350 GND.t225 246.506
R1691 GND.n166 GND.t117 246.506
R1692 GND.n250 GND.t201 246.506
R1693 GND.n512 GND.t267 246.506
R1694 GND.n456 GND.t255 246.506
R1695 GND GND.t64 234.952
R1696 GND.t138 GND.t66 234.952
R1697 GND.t94 GND.t166 227.833
R1698 GND.t202 GND.t149 227.833
R1699 GND.t24 GND 220.713
R1700 GND.t23 GND 220.713
R1701 GND.t73 GND.t85 220.713
R1702 GND.t89 GND 220.713
R1703 GND.t133 GND.t144 220.713
R1704 GND GND.t102 220.713
R1705 GND.t116 GND.t43 213.593
R1706 GND.n172 GND.n171 210.601
R1707 GND.n117 GND.n116 210.601
R1708 GND.n197 GND.n196 210.601
R1709 GND.n439 GND.n438 210.601
R1710 GND.n36 GND.n35 210.601
R1711 GND.n165 GND.n164 210.601
R1712 GND.n226 GND.n225 210.601
R1713 GND.n7 GND.n6 210.601
R1714 GND.n479 GND.n455 210.601
R1715 GND.n236 GND.n235 208.553
R1716 GND.n180 GND.n179 204.457
R1717 GND.n160 GND.n159 204.457
R1718 GND.n67 GND.n66 204.457
R1719 GND.n326 GND.n325 204.457
R1720 GND.n206 GND.n205 204.457
R1721 GND.n389 GND.n20 204.457
R1722 GND.n357 GND.n32 204.457
R1723 GND.n338 GND.n40 204.457
R1724 GND.n300 GND.n299 204.457
R1725 GND.n244 GND.n243 204.457
R1726 GND.n263 GND.n262 204.457
R1727 GND.n524 GND.n2 204.457
R1728 GND.n506 GND.n10 204.457
R1729 GND.n452 GND.n451 204.457
R1730 GND.n101 GND.n100 200.127
R1731 GND.n423 GND.n422 200.127
R1732 GND.n275 GND.n274 200.127
R1733 GND.n466 GND.n460 200.127
R1734 GND.n406 GND.n405 199.739
R1735 GND.n384 GND.n383 199.739
R1736 GND.n361 GND.n30 199.739
R1737 GND.n84 GND.n83 199.739
R1738 GND.n63 GND.n62 199.739
R1739 GND.n48 GND.n47 199.739
R1740 GND.t124 GND.t240 199.353
R1741 GND.t80 GND 199.353
R1742 GND GND.t130 199.353
R1743 GND.t246 GND.t91 185.113
R1744 GND.t147 GND.t220 185.113
R1745 GND.n417 GND.n416 185
R1746 GND.n415 GND.n414 185
R1747 GND.n400 GND.n399 185
R1748 GND.n398 GND.n397 185
R1749 GND.n371 GND.n370 185
R1750 GND.n373 GND.n372 185
R1751 GND.n95 GND.n94 185
R1752 GND.n93 GND.n92 185
R1753 GND.n78 GND.n77 185
R1754 GND.n76 GND.n75 185
R1755 GND.n135 GND.n134 185
R1756 GND.n137 GND.n136 185
R1757 GND.t158 GND.t176 177.994
R1758 GND.t70 GND.t248 177.994
R1759 GND.t178 GND.t216 177.994
R1760 GND.t222 GND.t75 177.994
R1761 GND GND.t94 170.875
R1762 GND GND.t83 170.875
R1763 GND GND.t89 170.875
R1764 GND.t149 GND 170.875
R1765 GND.t6 GND 170.875
R1766 GND.t102 GND 170.875
R1767 GND.n151 GND.t59 158.361
R1768 GND.n145 GND.t55 158.361
R1769 GND.n130 GND.t213 158.361
R1770 GND.n57 GND.t161 158.361
R1771 GND.n378 GND.t257 158.361
R1772 GND.n24 GND.t219 158.361
R1773 GND.n306 GND.t243 158.361
R1774 GND.n312 GND.t141 158.361
R1775 GND.n498 GND.t237 158.361
R1776 GND.n492 GND.t229 158.361
R1777 GND.n106 GND.t249 156.915
R1778 GND.n428 GND.t223 156.915
R1779 GND.n280 GND.t197 156.915
R1780 GND.n458 GND.t265 156.915
R1781 GND.n110 GND.t211 154.131
R1782 GND.n432 GND.t261 154.131
R1783 GND.n284 GND.t239 154.131
R1784 GND.n473 GND.t231 154.131
R1785 GND.n229 GND.t61 150.922
R1786 GND.t45 GND.t29 149.516
R1787 GND.t56 GND.t31 142.395
R1788 GND.t142 GND 142.395
R1789 GND GND.t98 142.395
R1790 GND GND.t15 121.037
R1791 GND.n269 GND 121.037
R1792 GND.n223 GND.n222 114.377
R1793 GND.t21 GND.t47 113.916
R1794 GND.n222 GND.t63 108.505
R1795 GND.n235 GND.t51 101.43
R1796 GND.n372 GND.n371 97.1434
R1797 GND.n399 GND.n398 97.1434
R1798 GND.n416 GND.n415 97.1434
R1799 GND.n136 GND.n135 97.1434
R1800 GND.n77 GND.n76 97.1434
R1801 GND.n94 GND.n93 97.1434
R1802 GND.t174 GND.t210 92.5571
R1803 GND.t260 GND.t182 92.5571
R1804 GND.n405 GND.t183 74.2862
R1805 GND.n383 GND.t185 74.2862
R1806 GND.n30 GND.t191 74.2862
R1807 GND.n83 GND.t175 74.2862
R1808 GND.n62 GND.t173 74.2862
R1809 GND.n47 GND.t193 74.2862
R1810 GND.n179 GND.t125 72.8576
R1811 GND.n159 GND.t65 72.8576
R1812 GND.n66 GND.t72 72.8576
R1813 GND.n325 GND.t167 72.8576
R1814 GND.n205 GND.t77 72.8576
R1815 GND.n20 GND.t5 72.8576
R1816 GND.n32 GND.t203 72.8576
R1817 GND.n40 GND.t132 72.8576
R1818 GND.n299 GND.t35 72.8576
R1819 GND.n243 GND.t121 72.8576
R1820 GND.n262 GND.t42 72.8576
R1821 GND.n2 GND.t127 72.8576
R1822 GND.n10 GND.t253 72.8576
R1823 GND.n451 GND.t112 72.8576
R1824 GND GND.t50 64.0782
R1825 GND.n372 GND.t187 61.4291
R1826 GND.n398 GND.t135 61.4291
R1827 GND.n415 GND.t148 61.4291
R1828 GND.n136 GND.t82 61.4291
R1829 GND.n76 GND.t88 61.4291
R1830 GND.n93 GND.t92 61.4291
R1831 GND.n171 GND.t37 55.7148
R1832 GND.n116 GND.t159 55.7148
R1833 GND.n196 GND.t79 55.7148
R1834 GND.n438 GND.t217 55.7148
R1835 GND.n35 GND.t101 55.7148
R1836 GND.n164 GND.t137 55.7148
R1837 GND.n225 GND.t30 55.7148
R1838 GND.n6 GND.t115 55.7148
R1839 GND.n455 GND.t235 55.7148
R1840 GND.t93 GND.t160 49.8387
R1841 GND GND.t86 49.8387
R1842 GND.t218 GND.t168 49.8387
R1843 GND.t11 GND 49.8387
R1844 GND.n260 GND.n217 43.9358
R1845 GND.t136 GND 42.7189
R1846 GND.n222 GND.t46 38.7697
R1847 GND.n371 GND.t195 38.5719
R1848 GND.n399 GND.t179 38.5719
R1849 GND.n416 GND.t181 38.5719
R1850 GND.n135 GND.t189 38.5719
R1851 GND.n77 GND.t177 38.5719
R1852 GND.n94 GND.t171 38.5719
R1853 GND.t212 GND.t188 35.5992
R1854 GND.t194 GND.t256 35.5992
R1855 GND.n183 GND.n181 34.6358
R1856 GND.n174 GND.n173 34.6358
R1857 GND.n175 GND.n174 34.6358
R1858 GND.n177 GND.n175 34.6358
R1859 GND.n178 GND.n177 34.6358
R1860 GND.n169 GND.n168 34.6358
R1861 GND.n162 GND.n161 34.6358
R1862 GND.n163 GND.n162 34.6358
R1863 GND.n155 GND.n152 34.6358
R1864 GND.n156 GND.n155 34.6358
R1865 GND.n157 GND.n156 34.6358
R1866 GND.n147 GND.n146 34.6358
R1867 GND.n149 GND.n147 34.6358
R1868 GND.n150 GND.n149 34.6358
R1869 GND.n144 GND.n141 34.6358
R1870 GND.n231 GND.n230 34.6358
R1871 GND.n233 GND.n231 34.6358
R1872 GND.n234 GND.n233 34.6358
R1873 GND.n237 GND.n234 34.6358
R1874 GND.n218 GND.n217 34.6358
R1875 GND.n220 GND.n218 34.6358
R1876 GND.n221 GND.n220 34.6358
R1877 GND.n408 GND.n407 34.6358
R1878 GND.n410 GND.n408 34.6358
R1879 GND.n411 GND.n410 34.6358
R1880 GND.n402 GND.n401 34.6358
R1881 GND.n403 GND.n402 34.6358
R1882 GND.n391 GND.n18 34.6358
R1883 GND.n392 GND.n391 34.6358
R1884 GND.n393 GND.n392 34.6358
R1885 GND.n382 GND.n22 34.6358
R1886 GND.n385 GND.n382 34.6358
R1887 GND.n362 GND.n26 34.6358
R1888 GND.n368 GND.n26 34.6358
R1889 GND.n374 GND.n368 34.6358
R1890 GND.n86 GND.n85 34.6358
R1891 GND.n88 GND.n86 34.6358
R1892 GND.n89 GND.n88 34.6358
R1893 GND.n80 GND.n79 34.6358
R1894 GND.n81 GND.n80 34.6358
R1895 GND.n69 GND.n64 34.6358
R1896 GND.n70 GND.n69 34.6358
R1897 GND.n71 GND.n70 34.6358
R1898 GND.n133 GND.n54 34.6358
R1899 GND.n61 GND.n54 34.6358
R1900 GND.n51 GND.n49 34.6358
R1901 GND.n139 GND.n51 34.6358
R1902 GND.n139 GND.n138 34.6358
R1903 GND.n115 GND.n114 34.6358
R1904 GND.n124 GND.n123 34.6358
R1905 GND.n123 GND.n122 34.6358
R1906 GND.n122 GND.n68 34.6358
R1907 GND.n118 GND.n68 34.6358
R1908 GND.n129 GND.n128 34.6358
R1909 GND.n128 GND.n60 34.6358
R1910 GND.n59 GND.n58 34.6358
R1911 GND.n131 GND.n59 34.6358
R1912 GND.n324 GND.n46 34.6358
R1913 GND.n320 GND.n46 34.6358
R1914 GND.n320 GND.n319 34.6358
R1915 GND.n319 GND.n50 34.6358
R1916 GND.n191 GND.n45 34.6358
R1917 GND.n327 GND.n45 34.6358
R1918 GND.n195 GND.n188 34.6358
R1919 GND.n204 GND.n203 34.6358
R1920 GND.n203 GND.n186 34.6358
R1921 GND.n199 GND.n186 34.6358
R1922 GND.n199 GND.n198 34.6358
R1923 GND.n207 GND.n184 34.6358
R1924 GND.n437 GND.n436 34.6358
R1925 GND.n446 GND.n445 34.6358
R1926 GND.n445 GND.n444 34.6358
R1927 GND.n444 GND.n390 34.6358
R1928 GND.n440 GND.n390 34.6358
R1929 GND.n387 GND.n21 34.6358
R1930 GND.n388 GND.n387 34.6358
R1931 GND.n377 GND.n376 34.6358
R1932 GND.n379 GND.n377 34.6358
R1933 GND.n358 GND.n28 34.6358
R1934 GND.n364 GND.n28 34.6358
R1935 GND.n365 GND.n364 34.6358
R1936 GND.n366 GND.n365 34.6358
R1937 GND.n351 GND.n33 34.6358
R1938 GND.n356 GND.n33 34.6358
R1939 GND.n349 GND.n348 34.6358
R1940 GND.n339 GND.n38 34.6358
R1941 GND.n343 GND.n38 34.6358
R1942 GND.n344 GND.n343 34.6358
R1943 GND.n345 GND.n344 34.6358
R1944 GND.n337 GND.n336 34.6358
R1945 GND.n289 GND.n288 34.6358
R1946 GND.n298 GND.n154 34.6358
R1947 GND.n294 GND.n154 34.6358
R1948 GND.n294 GND.n293 34.6358
R1949 GND.n293 GND.n158 34.6358
R1950 GND.n305 GND.n148 34.6358
R1951 GND.n301 GND.n148 34.6358
R1952 GND.n311 GND.n143 34.6358
R1953 GND.n307 GND.n143 34.6358
R1954 GND.n242 GND.n232 34.6358
R1955 GND.n238 GND.n232 34.6358
R1956 GND.n238 GND.n142 34.6358
R1957 GND.n313 GND.n142 34.6358
R1958 GND.n249 GND.n227 34.6358
R1959 GND.n245 GND.n227 34.6358
R1960 GND.n252 GND.n251 34.6358
R1961 GND.n261 GND.n216 34.6358
R1962 GND.n257 GND.n216 34.6358
R1963 GND.n257 GND.n256 34.6358
R1964 GND.n256 GND.n219 34.6358
R1965 GND.n264 GND.n214 34.6358
R1966 GND.n526 GND.n525 34.6358
R1967 GND.n523 GND.n3 34.6358
R1968 GND.n519 GND.n3 34.6358
R1969 GND.n519 GND.n518 34.6358
R1970 GND.n518 GND.n4 34.6358
R1971 GND.n514 GND.n513 34.6358
R1972 GND.n511 GND.n8 34.6358
R1973 GND.n507 GND.n8 34.6358
R1974 GND.n505 GND.n504 34.6358
R1975 GND.n504 GND.n11 34.6358
R1976 GND.n500 GND.n11 34.6358
R1977 GND.n500 GND.n499 34.6358
R1978 GND.n497 GND.n13 34.6358
R1979 GND.n493 GND.n13 34.6358
R1980 GND.n491 GND.n490 34.6358
R1981 GND.n490 GND.n15 34.6358
R1982 GND.n486 GND.n485 34.6358
R1983 GND.n485 GND.n484 34.6358
R1984 GND.n484 GND.n453 34.6358
R1985 GND.n480 GND.n453 34.6358
R1986 GND.n478 GND.n477 34.6358
R1987 GND.n237 GND.n236 28.9887
R1988 GND.n228 GND.n223 27.4829
R1989 GND.n171 GND.t39 26.8576
R1990 GND.n116 GND.t69 26.8576
R1991 GND.n196 GND.t1 26.8576
R1992 GND.n438 GND.t97 26.8576
R1993 GND.n35 GND.t146 26.8576
R1994 GND.n164 GND.t18 26.8576
R1995 GND.n225 GND.t28 26.8576
R1996 GND.n6 GND.t108 26.8576
R1997 GND.n455 GND.t155 26.8576
R1998 GND.n101 GND.n99 25.977
R1999 GND.n99 GND.n98 25.977
R2000 GND.n106 GND.n82 25.977
R2001 GND.n423 GND.n421 25.977
R2002 GND.n421 GND.n420 25.977
R2003 GND.n428 GND.n404 25.977
R2004 GND.n275 GND.n273 25.977
R2005 GND.n273 GND.n272 25.977
R2006 GND.n280 GND.n170 25.977
R2007 GND.n472 GND.n458 25.977
R2008 GND.n466 GND.n465 25.977
R2009 GND.n465 GND.n462 25.977
R2010 GND.n235 GND.t53 25.9346
R2011 GND.n100 GND.t157 25.8467
R2012 GND.n422 GND.t215 25.8467
R2013 GND.n274 GND.t139 25.8467
R2014 GND.n460 GND.t233 25.8467
R2015 GND.n405 GND.t103 25.4291
R2016 GND.n383 GND.t7 25.4291
R2017 GND.n30 GND.t150 25.4291
R2018 GND.n83 GND.t90 25.4291
R2019 GND.n62 GND.t84 25.4291
R2020 GND.n47 GND.t95 25.4291
R2021 GND.n100 GND.t247 24.9236
R2022 GND.n422 GND.t221 24.9236
R2023 GND.n274 GND.t199 24.9236
R2024 GND.n460 GND.t263 24.9236
R2025 GND.n110 GND.n82 24.4711
R2026 GND.n111 GND.n110 24.4711
R2027 GND.n432 GND.n404 24.4711
R2028 GND.n433 GND.n432 24.4711
R2029 GND.n284 GND.n170 24.4711
R2030 GND.n285 GND.n284 24.4711
R2031 GND.n474 GND.n473 24.4711
R2032 GND.n473 GND.n472 24.4711
R2033 GND.n270 GND.n183 23.7181
R2034 GND.n229 GND.n228 23.7181
R2035 GND.n360 GND.n31 23.7181
R2036 GND.n329 GND.n43 23.7181
R2037 GND.n210 GND.n184 23.7181
R2038 GND.n336 GND.n334 23.7181
R2039 GND.n267 GND.n214 23.7181
R2040 GND.n526 GND.n0 23.7181
R2041 GND.n407 GND.n406 22.9652
R2042 GND.n384 GND.n18 22.9652
R2043 GND.n362 GND.n361 22.9652
R2044 GND.n85 GND.n84 22.9652
R2045 GND.n64 GND.n63 22.9652
R2046 GND.n49 GND.n48 22.9652
R2047 GND.n179 GND.t67 22.3257
R2048 GND.n159 GND.t123 22.3257
R2049 GND.n66 GND.t143 22.3257
R2050 GND.n325 GND.t13 22.3257
R2051 GND.n205 GND.t9 22.3257
R2052 GND.n20 GND.t99 22.3257
R2053 GND.n32 GND.t129 22.3257
R2054 GND.n40 GND.t3 22.3257
R2055 GND.n299 GND.t16 22.3257
R2056 GND.n243 GND.t20 22.3257
R2057 GND.n262 GND.t26 22.3257
R2058 GND.n2 GND.t106 22.3257
R2059 GND.n10 GND.t110 22.3257
R2060 GND.n451 GND.t153 22.3257
R2061 GND.n414 GND.n411 22.2496
R2062 GND.n397 GND.n393 22.2496
R2063 GND.n374 GND.n373 22.2496
R2064 GND.n92 GND.n89 22.2496
R2065 GND.n75 GND.n71 22.2496
R2066 GND.n138 GND.n137 22.2496
R2067 GND.n230 GND.n229 22.2123
R2068 GND.n236 GND.n141 21.4593
R2069 GND.n223 GND.n221 21.4593
R2070 GND.n406 GND.n403 21.4593
R2071 GND.n385 GND.n384 21.4593
R2072 GND.n361 GND.n360 21.4593
R2073 GND.n84 GND.n81 21.4593
R2074 GND.n63 GND.n61 21.4593
R2075 GND.n48 GND.n43 21.4593
R2076 GND GND.t81 21.3597
R2077 GND.t186 GND 21.3597
R2078 GND.n105 GND.n87 19.9534
R2079 GND.n427 GND.n409 19.9534
R2080 GND.n279 GND.n176 19.9534
R2081 GND.n468 GND.n467 19.9534
R2082 GND.n418 GND.n417 19.3757
R2083 GND.n96 GND.n95 19.3757
R2084 GND.n101 GND.n87 18.4476
R2085 GND.n423 GND.n409 18.4476
R2086 GND.n275 GND.n176 18.4476
R2087 GND.n467 GND.n466 18.4476
R2088 GND.n173 GND.n172 16.1887
R2089 GND.n118 GND.n117 16.1887
R2090 GND.n198 GND.n197 16.1887
R2091 GND.n440 GND.n439 16.1887
R2092 GND.n345 GND.n36 16.1887
R2093 GND.n165 GND.n158 16.1887
R2094 GND.n226 GND.n219 16.1887
R2095 GND.n7 GND.n4 16.1887
R2096 GND.n480 GND.n479 16.1887
R2097 GND.n168 GND.n167 15.0593
R2098 GND.n106 GND.n105 15.0593
R2099 GND.n114 GND.n74 15.0593
R2100 GND.n190 GND.n188 15.0593
R2101 GND.n428 GND.n427 15.0593
R2102 GND.n436 GND.n396 15.0593
R2103 GND.n350 GND.n349 15.0593
R2104 GND.n280 GND.n279 15.0593
R2105 GND.n288 GND.n166 15.0593
R2106 GND.n251 GND.n250 15.0593
R2107 GND.n513 GND.n512 15.0593
R2108 GND.n477 GND.n456 15.0593
R2109 GND.n468 GND.n458 15.0593
R2110 GND.n153 GND.n16 11.8775
R2111 GND.n316 GND.n314 11.8775
R2112 GND.n488 GND.n449 11.8566
R2113 GND.n315 GND.n12 11.854
R2114 GND.n401 GND.n400 11.7085
R2115 GND.n370 GND.n22 11.7085
R2116 GND.n79 GND.n78 11.7085
R2117 GND.n134 GND.n133 11.7085
R2118 GND.n317 GND.n316 11.3205
R2119 GND.n315 GND.n25 11.3205
R2120 GND.n449 GND.n448 11.3205
R2121 GND.n126 GND.n16 11.3205
R2122 GND.n146 GND.n145 10.5417
R2123 GND.n151 GND.n150 10.5417
R2124 GND.n131 GND.n130 10.5417
R2125 GND.n57 GND.n50 10.5417
R2126 GND.n379 GND.n378 10.5417
R2127 GND.n366 GND.n24 10.5417
R2128 GND.n307 GND.n306 10.5417
R2129 GND.n313 GND.n312 10.5417
R2130 GND.n499 GND.n498 10.5417
R2131 GND.n493 GND.n492 10.5417
R2132 GND.n181 GND.n180 9.41227
R2133 GND.n161 GND.n160 9.41227
R2134 GND.n67 GND.n60 9.41227
R2135 GND.n327 GND.n326 9.41227
R2136 GND.n207 GND.n206 9.41227
R2137 GND.n389 GND.n388 9.41227
R2138 GND.n357 GND.n356 9.41227
R2139 GND.n338 GND.n337 9.41227
R2140 GND.n301 GND.n300 9.41227
R2141 GND.n245 GND.n244 9.41227
R2142 GND.n264 GND.n263 9.41227
R2143 GND.n525 GND.n524 9.41227
R2144 GND.n507 GND.n506 9.41227
R2145 GND.n452 GND.n15 9.41227
R2146 GND.n210 GND 9.3031
R2147 GND GND.n334 9.3031
R2148 GND.n267 GND 9.3031
R2149 GND GND.n0 9.3031
R2150 GND.n209 GND.n184 9.3005
R2151 GND.n208 GND.n207 9.3005
R2152 GND.n204 GND.n185 9.3005
R2153 GND.n203 GND.n202 9.3005
R2154 GND.n201 GND.n186 9.3005
R2155 GND.n200 GND.n199 9.3005
R2156 GND.n198 GND.n187 9.3005
R2157 GND.n195 GND.n194 9.3005
R2158 GND.n193 GND.n188 9.3005
R2159 GND.n192 GND.n191 9.3005
R2160 GND.n189 GND.n45 9.3005
R2161 GND.n329 GND.n328 9.3005
R2162 GND.n323 GND.n43 9.3005
R2163 GND.n322 GND.n48 9.3005
R2164 GND.n321 GND.n49 9.3005
R2165 GND.n318 GND.n51 9.3005
R2166 GND.n317 GND.n139 9.3005
R2167 GND.n138 GND.n52 9.3005
R2168 GND.n55 GND.n53 9.3005
R2169 GND.n133 GND.n132 9.3005
R2170 GND.n56 GND.n54 9.3005
R2171 GND.n127 GND.n61 9.3005
R2172 GND.n126 GND.n63 9.3005
R2173 GND.n125 GND.n64 9.3005
R2174 GND.n69 GND.n65 9.3005
R2175 GND.n121 GND.n70 9.3005
R2176 GND.n120 GND.n71 9.3005
R2177 GND.n119 GND.n72 9.3005
R2178 GND.n79 GND.n73 9.3005
R2179 GND.n113 GND.n80 9.3005
R2180 GND.n112 GND.n81 9.3005
R2181 GND.n109 GND.n84 9.3005
R2182 GND.n108 GND.n85 9.3005
R2183 GND.n107 GND.n86 9.3005
R2184 GND.n104 GND.n88 9.3005
R2185 GND.n103 GND.n89 9.3005
R2186 GND.n102 GND.n90 9.3005
R2187 GND.n98 GND.n97 9.3005
R2188 GND.n99 GND.n91 9.3005
R2189 GND.n102 GND.n101 9.3005
R2190 GND.n103 GND.n87 9.3005
R2191 GND.n105 GND.n104 9.3005
R2192 GND.n107 GND.n106 9.3005
R2193 GND.n328 GND.n327 9.3005
R2194 GND.n324 GND.n323 9.3005
R2195 GND.n322 GND.n46 9.3005
R2196 GND.n321 GND.n320 9.3005
R2197 GND.n319 GND.n318 9.3005
R2198 GND.n317 GND.n50 9.3005
R2199 GND.n58 GND.n52 9.3005
R2200 GND.n59 GND.n55 9.3005
R2201 GND.n132 GND.n131 9.3005
R2202 GND.n129 GND.n56 9.3005
R2203 GND.n128 GND.n127 9.3005
R2204 GND.n126 GND.n60 9.3005
R2205 GND.n125 GND.n124 9.3005
R2206 GND.n123 GND.n65 9.3005
R2207 GND.n122 GND.n121 9.3005
R2208 GND.n120 GND.n68 9.3005
R2209 GND.n119 GND.n118 9.3005
R2210 GND.n115 GND.n73 9.3005
R2211 GND.n114 GND.n113 9.3005
R2212 GND.n112 GND.n111 9.3005
R2213 GND.n110 GND.n109 9.3005
R2214 GND.n108 GND.n82 9.3005
R2215 GND.n336 GND.n335 9.3005
R2216 GND.n337 GND.n39 9.3005
R2217 GND.n340 GND.n339 9.3005
R2218 GND.n341 GND.n38 9.3005
R2219 GND.n343 GND.n342 9.3005
R2220 GND.n344 GND.n37 9.3005
R2221 GND.n346 GND.n345 9.3005
R2222 GND.n348 GND.n347 9.3005
R2223 GND.n349 GND.n34 9.3005
R2224 GND.n352 GND.n351 9.3005
R2225 GND.n353 GND.n33 9.3005
R2226 GND.n355 GND.n31 9.3005
R2227 GND.n360 GND.n359 9.3005
R2228 GND.n361 GND.n29 9.3005
R2229 GND.n363 GND.n362 9.3005
R2230 GND.n27 GND.n26 9.3005
R2231 GND.n368 GND.n367 9.3005
R2232 GND.n375 GND.n374 9.3005
R2233 GND.n369 GND.n23 9.3005
R2234 GND.n380 GND.n22 9.3005
R2235 GND.n382 GND.n381 9.3005
R2236 GND.n386 GND.n385 9.3005
R2237 GND.n384 GND.n17 9.3005
R2238 GND.n447 GND.n18 9.3005
R2239 GND.n391 GND.n19 9.3005
R2240 GND.n443 GND.n392 9.3005
R2241 GND.n442 GND.n393 9.3005
R2242 GND.n441 GND.n394 9.3005
R2243 GND.n401 GND.n395 9.3005
R2244 GND.n435 GND.n402 9.3005
R2245 GND.n434 GND.n403 9.3005
R2246 GND.n431 GND.n406 9.3005
R2247 GND.n430 GND.n407 9.3005
R2248 GND.n429 GND.n408 9.3005
R2249 GND.n426 GND.n410 9.3005
R2250 GND.n425 GND.n411 9.3005
R2251 GND.n424 GND.n412 9.3005
R2252 GND.n420 GND.n419 9.3005
R2253 GND.n421 GND.n413 9.3005
R2254 GND.n424 GND.n423 9.3005
R2255 GND.n425 GND.n409 9.3005
R2256 GND.n427 GND.n426 9.3005
R2257 GND.n429 GND.n428 9.3005
R2258 GND.n356 GND.n355 9.3005
R2259 GND.n359 GND.n358 9.3005
R2260 GND.n29 GND.n28 9.3005
R2261 GND.n364 GND.n363 9.3005
R2262 GND.n365 GND.n27 9.3005
R2263 GND.n367 GND.n366 9.3005
R2264 GND.n376 GND.n375 9.3005
R2265 GND.n377 GND.n23 9.3005
R2266 GND.n380 GND.n379 9.3005
R2267 GND.n381 GND.n21 9.3005
R2268 GND.n387 GND.n386 9.3005
R2269 GND.n388 GND.n17 9.3005
R2270 GND.n447 GND.n446 9.3005
R2271 GND.n445 GND.n19 9.3005
R2272 GND.n444 GND.n443 9.3005
R2273 GND.n442 GND.n390 9.3005
R2274 GND.n441 GND.n440 9.3005
R2275 GND.n437 GND.n395 9.3005
R2276 GND.n436 GND.n435 9.3005
R2277 GND.n434 GND.n433 9.3005
R2278 GND.n432 GND.n431 9.3005
R2279 GND.n430 GND.n404 9.3005
R2280 GND.n266 GND.n214 9.3005
R2281 GND.n265 GND.n264 9.3005
R2282 GND.n259 GND.n217 9.3005
R2283 GND.n258 GND.n218 9.3005
R2284 GND.n255 GND.n220 9.3005
R2285 GND.n254 GND.n221 9.3005
R2286 GND.n253 GND.n223 9.3005
R2287 GND.n228 GND.n224 9.3005
R2288 GND.n248 GND.n229 9.3005
R2289 GND.n247 GND.n230 9.3005
R2290 GND.n246 GND.n231 9.3005
R2291 GND.n241 GND.n233 9.3005
R2292 GND.n240 GND.n234 9.3005
R2293 GND.n239 GND.n237 9.3005
R2294 GND.n236 GND.n140 9.3005
R2295 GND.n314 GND.n141 9.3005
R2296 GND.n310 GND.n144 9.3005
R2297 GND.n309 GND.n146 9.3005
R2298 GND.n308 GND.n147 9.3005
R2299 GND.n304 GND.n149 9.3005
R2300 GND.n303 GND.n150 9.3005
R2301 GND.n302 GND.n152 9.3005
R2302 GND.n297 GND.n155 9.3005
R2303 GND.n296 GND.n156 9.3005
R2304 GND.n295 GND.n157 9.3005
R2305 GND.n292 GND.n161 9.3005
R2306 GND.n291 GND.n162 9.3005
R2307 GND.n290 GND.n163 9.3005
R2308 GND.n287 GND.n168 9.3005
R2309 GND.n286 GND.n169 9.3005
R2310 GND.n283 GND.n173 9.3005
R2311 GND.n282 GND.n174 9.3005
R2312 GND.n281 GND.n175 9.3005
R2313 GND.n278 GND.n177 9.3005
R2314 GND.n277 GND.n178 9.3005
R2315 GND.n276 GND.n181 9.3005
R2316 GND.n183 GND.n182 9.3005
R2317 GND.n272 GND.n271 9.3005
R2318 GND.n273 GND.n182 9.3005
R2319 GND.n276 GND.n275 9.3005
R2320 GND.n277 GND.n176 9.3005
R2321 GND.n279 GND.n278 9.3005
R2322 GND.n281 GND.n280 9.3005
R2323 GND.n261 GND.n260 9.3005
R2324 GND.n259 GND.n216 9.3005
R2325 GND.n258 GND.n257 9.3005
R2326 GND.n256 GND.n255 9.3005
R2327 GND.n254 GND.n219 9.3005
R2328 GND.n253 GND.n252 9.3005
R2329 GND.n251 GND.n224 9.3005
R2330 GND.n249 GND.n248 9.3005
R2331 GND.n247 GND.n227 9.3005
R2332 GND.n246 GND.n245 9.3005
R2333 GND.n242 GND.n241 9.3005
R2334 GND.n240 GND.n232 9.3005
R2335 GND.n239 GND.n238 9.3005
R2336 GND.n142 GND.n140 9.3005
R2337 GND.n314 GND.n313 9.3005
R2338 GND.n311 GND.n310 9.3005
R2339 GND.n309 GND.n143 9.3005
R2340 GND.n308 GND.n307 9.3005
R2341 GND.n305 GND.n304 9.3005
R2342 GND.n303 GND.n148 9.3005
R2343 GND.n302 GND.n301 9.3005
R2344 GND.n298 GND.n297 9.3005
R2345 GND.n296 GND.n154 9.3005
R2346 GND.n295 GND.n294 9.3005
R2347 GND.n293 GND.n292 9.3005
R2348 GND.n291 GND.n158 9.3005
R2349 GND.n290 GND.n289 9.3005
R2350 GND.n288 GND.n287 9.3005
R2351 GND.n286 GND.n285 9.3005
R2352 GND.n284 GND.n283 9.3005
R2353 GND.n282 GND.n170 9.3005
R2354 GND.n271 GND.n270 9.3005
R2355 GND.n463 GND.n462 9.3005
R2356 GND.n465 GND.n464 9.3005
R2357 GND.n466 GND.n461 9.3005
R2358 GND.n467 GND.n459 9.3005
R2359 GND.n469 GND.n468 9.3005
R2360 GND.n470 GND.n458 9.3005
R2361 GND.n527 GND.n526 9.3005
R2362 GND.n525 GND.n1 9.3005
R2363 GND.n523 GND.n522 9.3005
R2364 GND.n521 GND.n3 9.3005
R2365 GND.n520 GND.n519 9.3005
R2366 GND.n518 GND.n517 9.3005
R2367 GND.n516 GND.n4 9.3005
R2368 GND.n515 GND.n514 9.3005
R2369 GND.n513 GND.n5 9.3005
R2370 GND.n511 GND.n510 9.3005
R2371 GND.n509 GND.n8 9.3005
R2372 GND.n508 GND.n507 9.3005
R2373 GND.n505 GND.n9 9.3005
R2374 GND.n504 GND.n503 9.3005
R2375 GND.n502 GND.n11 9.3005
R2376 GND.n501 GND.n500 9.3005
R2377 GND.n499 GND.n12 9.3005
R2378 GND.n497 GND.n496 9.3005
R2379 GND.n495 GND.n13 9.3005
R2380 GND.n494 GND.n493 9.3005
R2381 GND.n491 GND.n14 9.3005
R2382 GND.n490 GND.n489 9.3005
R2383 GND.n488 GND.n15 9.3005
R2384 GND.n487 GND.n486 9.3005
R2385 GND.n485 GND.n450 9.3005
R2386 GND.n484 GND.n483 9.3005
R2387 GND.n482 GND.n453 9.3005
R2388 GND.n481 GND.n480 9.3005
R2389 GND.n478 GND.n454 9.3005
R2390 GND.n477 GND.n476 9.3005
R2391 GND.n475 GND.n474 9.3005
R2392 GND.n473 GND.n457 9.3005
R2393 GND.n472 GND.n471 9.3005
R2394 GND GND.t41 7.12024
R2395 GND GND.t120 7.12024
R2396 GND GND.t34 7.12024
R2397 GND.n152 GND.n151 6.77697
R2398 GND.n145 GND.n144 6.77697
R2399 GND.n130 GND.n129 6.77697
R2400 GND.n58 GND.n57 6.77697
R2401 GND.n378 GND.n21 6.77697
R2402 GND.n376 GND.n24 6.77697
R2403 GND.n306 GND.n305 6.77697
R2404 GND.n312 GND.n311 6.77697
R2405 GND.n498 GND.n497 6.77697
R2406 GND.n492 GND.n491 6.77697
R2407 GND.n180 GND.n178 6.4005
R2408 GND.n160 GND.n157 6.4005
R2409 GND.n124 GND.n67 6.4005
R2410 GND.n326 GND.n324 6.4005
R2411 GND.n206 GND.n204 6.4005
R2412 GND.n446 GND.n389 6.4005
R2413 GND.n358 GND.n357 6.4005
R2414 GND.n339 GND.n338 6.4005
R2415 GND.n300 GND.n298 6.4005
R2416 GND.n244 GND.n242 6.4005
R2417 GND.n263 GND.n261 6.4005
R2418 GND.n524 GND.n523 6.4005
R2419 GND.n506 GND.n505 6.4005
R2420 GND.n486 GND.n452 6.4005
R2421 GND.n417 GND.n412 4.35795
R2422 GND.n400 GND.n394 4.35795
R2423 GND.n370 GND.n369 4.35795
R2424 GND.n95 GND.n90 4.35795
R2425 GND.n78 GND.n72 4.35795
R2426 GND.n134 GND.n53 4.35795
R2427 GND.n172 GND.n169 2.25932
R2428 GND.n117 GND.n115 2.25932
R2429 GND.n197 GND.n195 2.25932
R2430 GND.n439 GND.n437 2.25932
R2431 GND.n348 GND.n36 2.25932
R2432 GND.n289 GND.n165 2.25932
R2433 GND.n252 GND.n226 2.25932
R2434 GND.n514 GND.n7 2.25932
R2435 GND.n479 GND.n478 2.25932
R2436 GND.n414 GND.n412 1.8161
R2437 GND.n397 GND.n394 1.8161
R2438 GND.n373 GND.n369 1.8161
R2439 GND.n92 GND.n90 1.8161
R2440 GND.n75 GND.n72 1.8161
R2441 GND.n137 GND.n53 1.8161
R2442 GND.n167 GND.n163 1.50638
R2443 GND.n111 GND.n74 1.50638
R2444 GND.n191 GND.n190 1.50638
R2445 GND.n433 GND.n396 1.50638
R2446 GND.n351 GND.n350 1.50638
R2447 GND.n285 GND.n166 1.50638
R2448 GND.n250 GND.n249 1.50638
R2449 GND.n512 GND.n511 1.50638
R2450 GND.n474 GND.n456 1.50638
R2451 GND.n316 GND.n315 0.558407
R2452 GND.n449 GND.n16 0.556667
R2453 GND.n44 GND 0.479667
R2454 GND.n354 GND 0.479667
R2455 GND.n215 GND 0.359875
R2456 GND.n209 GND.n208 0.120292
R2457 GND.n208 GND.n185 0.120292
R2458 GND.n202 GND.n185 0.120292
R2459 GND.n202 GND.n201 0.120292
R2460 GND.n200 GND.n187 0.120292
R2461 GND.n194 GND.n187 0.120292
R2462 GND.n194 GND.n193 0.120292
R2463 GND.n193 GND.n192 0.120292
R2464 GND.n335 GND.n39 0.120292
R2465 GND.n340 GND.n39 0.120292
R2466 GND.n341 GND.n340 0.120292
R2467 GND.n342 GND.n341 0.120292
R2468 GND.n346 GND.n37 0.120292
R2469 GND.n347 GND.n346 0.120292
R2470 GND.n347 GND.n34 0.120292
R2471 GND.n352 GND.n34 0.120292
R2472 GND.n266 GND.n265 0.120292
R2473 GND.n527 GND.n1 0.120292
R2474 GND.n522 GND.n1 0.120292
R2475 GND.n522 GND.n521 0.120292
R2476 GND.n521 GND.n520 0.120292
R2477 GND.n517 GND.n516 0.120292
R2478 GND.n516 GND.n515 0.120292
R2479 GND.n515 GND.n5 0.120292
R2480 GND.n510 GND.n5 0.120292
R2481 GND.n509 GND.n508 0.120292
R2482 GND.n508 GND.n9 0.120292
R2483 GND.n503 GND.n9 0.120292
R2484 GND.n503 GND.n502 0.120292
R2485 GND.n501 GND.n12 0.120292
R2486 GND.n496 GND.n12 0.120292
R2487 GND.n495 GND.n494 0.120292
R2488 GND.n494 GND.n14 0.120292
R2489 GND.n489 GND.n488 0.120292
R2490 GND.n488 GND.n487 0.120292
R2491 GND.n487 GND.n450 0.120292
R2492 GND.n483 GND.n450 0.120292
R2493 GND.n482 GND.n481 0.120292
R2494 GND.n481 GND.n454 0.120292
R2495 GND.n476 GND.n454 0.120292
R2496 GND.n476 GND.n475 0.120292
R2497 GND.n471 GND.n457 0.120292
R2498 GND.n471 GND.n470 0.120292
R2499 GND.n469 GND.n459 0.120292
R2500 GND.n461 GND.n459 0.120292
R2501 GND.n464 GND.n461 0.120292
R2502 GND.n464 GND.n463 0.120292
R2503 GND GND.n209 0.0603958
R2504 GND GND.n200 0.0603958
R2505 GND GND.n189 0.0603958
R2506 GND.n189 GND.n44 0.0603958
R2507 GND.n322 GND.n321 0.0603958
R2508 GND.n318 GND.n317 0.0603958
R2509 GND.n317 GND.n52 0.0603958
R2510 GND.n132 GND.n55 0.0603958
R2511 GND.n132 GND.n56 0.0603958
R2512 GND.n126 GND.n125 0.0603958
R2513 GND.n125 GND.n65 0.0603958
R2514 GND.n121 GND.n65 0.0603958
R2515 GND.n120 GND.n119 0.0603958
R2516 GND.n119 GND.n73 0.0603958
R2517 GND.n113 GND.n73 0.0603958
R2518 GND.n109 GND.n108 0.0603958
R2519 GND.n108 GND.n107 0.0603958
R2520 GND.n104 GND.n103 0.0603958
R2521 GND.n103 GND.n102 0.0603958
R2522 GND.n102 GND.n91 0.0603958
R2523 GND.n335 GND 0.0603958
R2524 GND GND.n37 0.0603958
R2525 GND.n353 GND 0.0603958
R2526 GND.n354 GND.n353 0.0603958
R2527 GND.n363 GND.n29 0.0603958
R2528 GND.n367 GND.n27 0.0603958
R2529 GND.n380 GND.n23 0.0603958
R2530 GND.n381 GND.n380 0.0603958
R2531 GND.n447 GND.n19 0.0603958
R2532 GND.n443 GND.n19 0.0603958
R2533 GND.n442 GND.n441 0.0603958
R2534 GND.n441 GND.n395 0.0603958
R2535 GND.n435 GND.n395 0.0603958
R2536 GND.n431 GND.n430 0.0603958
R2537 GND.n430 GND.n429 0.0603958
R2538 GND.n426 GND.n425 0.0603958
R2539 GND.n425 GND.n424 0.0603958
R2540 GND.n424 GND.n413 0.0603958
R2541 GND GND.n266 0.0603958
R2542 GND.n265 GND.n215 0.0603958
R2543 GND.n259 GND.n258 0.0603958
R2544 GND.n255 GND.n254 0.0603958
R2545 GND.n254 GND.n253 0.0603958
R2546 GND.n253 GND.n224 0.0603958
R2547 GND.n247 GND.n246 0.0603958
R2548 GND.n240 GND.n239 0.0603958
R2549 GND.n314 GND.n140 0.0603958
R2550 GND.n309 GND.n308 0.0603958
R2551 GND.n303 GND.n302 0.0603958
R2552 GND.n296 GND.n295 0.0603958
R2553 GND.n292 GND.n291 0.0603958
R2554 GND.n287 GND.n286 0.0603958
R2555 GND.n283 GND.n282 0.0603958
R2556 GND.n278 GND.n277 0.0603958
R2557 GND.n277 GND.n276 0.0603958
R2558 GND.n276 GND.n182 0.0603958
R2559 GND GND.n527 0.0603958
R2560 GND.n517 GND 0.0603958
R2561 GND GND.n509 0.0603958
R2562 GND GND.n501 0.0603958
R2563 GND GND.n495 0.0603958
R2564 GND.n489 GND 0.0603958
R2565 GND GND.n482 0.0603958
R2566 GND.n457 GND 0.0603958
R2567 GND GND.n469 0.0603958
R2568 GND.n375 GND.n25 0.0590938
R2569 GND.n448 GND.n447 0.0590938
R2570 GND.n97 GND.n96 0.0503767
R2571 GND.n419 GND.n418 0.0503767
R2572 GND GND.n259 0.0493281
R2573 GND GND.n240 0.0493281
R2574 GND GND.n296 0.0493281
R2575 GND.n287 GND 0.0493281
R2576 GND GND.n322 0.0486771
R2577 GND GND.n126 0.0486771
R2578 GND GND.n29 0.0486771
R2579 GND GND.n17 0.0486771
R2580 GND.n328 GND.n44 0.0304479
R2581 GND.n323 GND 0.0304479
R2582 GND.n318 GND 0.0304479
R2583 GND.n55 GND 0.0304479
R2584 GND.n127 GND 0.0304479
R2585 GND GND.n120 0.0304479
R2586 GND.n113 GND 0.0304479
R2587 GND GND.n112 0.0304479
R2588 GND.n109 GND 0.0304479
R2589 GND.n104 GND 0.0304479
R2590 GND.n355 GND.n354 0.0304479
R2591 GND.n359 GND 0.0304479
R2592 GND GND.n27 0.0304479
R2593 GND GND.n23 0.0304479
R2594 GND.n386 GND 0.0304479
R2595 GND GND.n442 0.0304479
R2596 GND.n435 GND 0.0304479
R2597 GND GND.n434 0.0304479
R2598 GND.n431 GND 0.0304479
R2599 GND.n426 GND 0.0304479
R2600 GND.n260 GND.n215 0.0304479
R2601 GND.n255 GND 0.0304479
R2602 GND GND.n224 0.0304479
R2603 GND.n248 GND 0.0304479
R2604 GND GND.n247 0.0304479
R2605 GND.n246 GND 0.0304479
R2606 GND.n241 GND 0.0304479
R2607 GND GND.n140 0.0304479
R2608 GND.n314 GND 0.0304479
R2609 GND.n310 GND 0.0304479
R2610 GND GND.n309 0.0304479
R2611 GND.n308 GND 0.0304479
R2612 GND.n304 GND 0.0304479
R2613 GND GND.n303 0.0304479
R2614 GND.n297 GND 0.0304479
R2615 GND.n292 GND 0.0304479
R2616 GND.n291 GND 0.0304479
R2617 GND GND.n290 0.0304479
R2618 GND.n283 GND 0.0304479
R2619 GND.n282 GND 0.0304479
R2620 GND GND.n281 0.0304479
R2621 GND.n278 GND 0.0304479
R2622 GND GND.n182 0.0304479
R2623 GND.n271 GND 0.0304479
R2624 GND.n201 GND 0.0226354
R2625 GND.n192 GND 0.0226354
R2626 GND.n342 GND 0.0226354
R2627 GND GND.n352 0.0226354
R2628 GND.n520 GND 0.0226354
R2629 GND.n510 GND 0.0226354
R2630 GND.n502 GND 0.0226354
R2631 GND.n496 GND 0.0226354
R2632 GND GND.n14 0.0226354
R2633 GND.n483 GND 0.0226354
R2634 GND.n475 GND 0.0226354
R2635 GND.n463 GND 0.0226354
R2636 GND.n470 GND 0.0213333
R2637 GND.n323 GND 0.0122188
R2638 GND.n127 GND 0.0122188
R2639 GND.n359 GND 0.0122188
R2640 GND.n386 GND 0.0122188
R2641 GND.n321 GND 0.0115677
R2642 GND GND.n52 0.0115677
R2643 GND GND.n56 0.0115677
R2644 GND.n121 GND 0.0115677
R2645 GND.n112 GND 0.0115677
R2646 GND.n97 GND 0.0115677
R2647 GND.n363 GND 0.0115677
R2648 GND.n375 GND 0.0115677
R2649 GND.n381 GND 0.0115677
R2650 GND.n443 GND 0.0115677
R2651 GND.n434 GND 0.0115677
R2652 GND.n419 GND 0.0115677
R2653 GND.n258 GND 0.0115677
R2654 GND.n241 GND 0.0115677
R2655 GND.n239 GND 0.0115677
R2656 GND.n310 GND 0.0115677
R2657 GND.n304 GND 0.0115677
R2658 GND.n297 GND 0.0115677
R2659 GND.n295 GND 0.0115677
R2660 GND.n290 GND 0.0115677
R2661 GND.n286 GND 0.0115677
R2662 GND.n271 GND 0.0115677
R2663 GND.n96 GND.n91 0.0114518
R2664 GND.n418 GND.n413 0.0114518
R2665 GND.n107 GND 0.0109167
R2666 GND.n429 GND 0.0109167
R2667 GND.n248 GND 0.0109167
R2668 GND.n281 GND 0.0109167
R2669 GND GND.n153 0.0102656
R2670 GND.n328 GND 0.00180208
R2671 GND.n355 GND 0.00180208
R2672 GND.n367 GND.n25 0.00180208
R2673 GND.n448 GND.n17 0.00180208
R2674 GND.n260 GND 0.00180208
R2675 GND.n302 GND.n153 0.00180208
C0 a_991_n1786# x4.Z[1] 0.1241f
C1 Y[3] x17.X 0.24799f
C2 x13.A1 a_417_n1786# 0.20947f
C3 VDD a_2361_n3717# 0.21433f
C4 Z0[2] Z3[2] 0.41216f
C5 a_273_n313# VDD 0.21536f
C6 A[4] a_898_n2215# 0.1164f
C7 x10.B VDD 0.38943f
C8 x3.x9.A x3.x8.A 0.16041f
C9 x4.Z[1] x13.A0 0.6016f
C10 A[11] x2.x4.A 0.18756f
C11 A[7] Z1[2] 0.10344f
C12 x16.A0 VDD 0.46232f
C13 a_2361_123# A[12] 0.18261f
C14 Y[3] x13.A1 0.11791f
C15 a_3281_n1157# VDD 0.21542f
C16 a_2830_345# VDD 0.14717f
C17 A[13] A[12] 1.03876f
C18 a_2830_n2215# VDD 0.14709f
C19 A[14] VDD 0.58485f
C20 VDD x4.x9.B 0.27937f
C21 x4.x8.A x4.x9.A 0.16041f
C22 a_2830_n2215# x3.x9.B 0.1195f
C23 x4.x8.A a_2830_n3495# 0.24515f
C24 A[12] A[15] 0.73152f
C25 VDD a_163_n1786# 0.16445f
C26 x16.X Z1[0] 0.11754f
C27 VDD x17.X 0.27906f
C28 a_898_n935# x2.x4.B 0.12052f
C29 x16.A1 a_417_n3066# 0.20523f
C30 A[2] Z0[2] 0.43081f
C31 VDD x2.x9.A 1.09227f
C32 a_1193_n313# x9.Y 0.2034f
C33 a_2830_n935# VDD 0.15271f
C34 A[5] x3.x7.A 0.1005f
C35 A[3] Z0[2] 0.10352f
C36 A[4] a_2361_n2437# 0.18261f
C37 A[5] VDD 0.29524f
C38 x10.B a_751_n313# 0.10791f
C39 A[7] x3.x4.B 0.21158f
C40 Y[3] Z1[2] 0.10057f
C41 a_417_n1786# Y[2] 0.34989f
C42 A[6] x3.x8.A 0.26778f
C43 x13.A1 VDD 1.07971f
C44 x11.B a_1193_n313# 0.13074f
C45 a_3281_123# VDD 0.2148f
C46 x3.x4.B a_898_n2215# 0.12052f
C47 Y[3] Z3[2] 1.03157f
C48 x9.Y x8.Y 0.18323f
C49 A[4] x3.x7.A 0.15452f
C50 A[0] a_2361_n3717# 0.18261f
C51 A[4] VDD 0.24772f
C52 Y[3] a_1819_n1786# 0.21757f
C53 Y[3] Y[2] 1.26708f
C54 x17.X a_1819_n3066# 0.30929f
C55 x16.A0 x4.Z[1] 0.27923f
C56 Z3[2] a_2193_n313# 0.21197f
C57 A[6] a_2830_n2215# 0.11164f
C58 x1.x8.A VDD 0.19629f
C59 VDD a_163_n3066# 0.1552f
C60 x13.A1 Z2[2] 0.2861f
C61 x1.x4.A VDD 0.87316f
C62 x11.B x8.Y 0.21712f
C63 x1.x9.B VDD 0.27969f
C64 A[3] A[2] 0.38787f
C65 x1.x4.A x1.x4.B 0.38043f
C66 x2.x4.B VDD 0.27878f
C67 Z1[2] VDD 1.43975f
C68 VDD a_3281_n3717# 0.21416f
C69 a_2073_n3066# x17.X 0.18855f
C70 x16.A1 x16.A0 1.4266f
C71 Z1[2] x3.Z[1] 0.36129f
C72 x13.X Y[2] 0.1333f
C73 x4.x7.A a_2361_n3717# 0.10994f
C74 a_1245_n3066# Z0[0] 0.20363f
C75 x16.A1 a_3281_n1157# 0.11793f
C76 a_898_345# VDD 0.16335f
C77 x13.A1 a_1349_n1157# 0.11292f
C78 x16.A0 Z1[0] 0.54939f
C79 Z0[2] VDD 1.24734f
C80 x1.x9.A x13.A0 0.24372f
C81 x2.x7.A VDD 0.29891f
C82 a_898_345# x1.x4.B 0.12052f
C83 Z3[2] VDD 2.01237f
C84 A[10] x2.x9.A 0.15469f
C85 A[6] A[5] 1.39409f
C86 a_1819_n1786# VDD 0.15779f
C87 Y[2] VDD 2.86049f
C88 x1.x7.A VDD 0.29631f
C89 A[10] a_2830_n935# 0.11164f
C90 Y[2] a_991_n3066# 0.22524f
C91 A[14] A[12] 0.17687f
C92 Z1[2] Y[4] 0.23982f
C93 Z1[2] Z2[2] 0.85233f
C94 x16.A0 Z0[0] 0.27318f
C95 x4.x9.B x4.x9.A 0.35353f
C96 x13.A1 x4.Z[1] 0.8258f
C97 Z0[2] Y[4] 0.17623f
C98 x4.x9.B a_2830_n3495# 0.1195f
C99 x13.A1 A[10] 0.56219f
C100 A[13] A[15] 0.18211f
C101 Z3[2] Y[4] 0.21618f
C102 A[7] VDD 0.3696f
C103 x17.X Z1[0] 0.10776f
C104 Z0[2] Z2[2] 0.32985f
C105 x3.x4.B VDD 0.27824f
C106 Z2[2] Z3[2] 1.30884f
C107 Y[1] VDD 0.35054f
C108 A[6] A[4] 0.17686f
C109 a_1349_n1157# x2.x4.B 0.22515f
C110 a_898_n2215# VDD 0.16737f
C111 a_1349_123# VDD 0.21234f
C112 A[2] VDD 0.62034f
C113 a_417_n1786# VDD 0.12021f
C114 A[3] VDD 0.36683f
C115 a_1349_123# x1.x4.B 0.22515f
C116 Y[3] x13.X 0.31674f
C117 A[3] x4.x4.B 0.21158f
C118 A[6] Z1[2] 0.4292f
C119 x2.x9.B a_3281_n1157# 0.23074f
C120 a_898_n935# VDD 0.16786f
C121 x2.x7.A a_2361_n1157# 0.10994f
C122 Z0[2] A[1] 0.25513f
C123 Y[3] a_2073_n1786# 0.32174f
C124 x16.A1 a_163_n3066# 0.11332f
C125 Y[3] VDD 3.32059f
C126 x13.A1 A[8] 0.34222f
C127 Z0[2] x4.Z[1] 0.48417f
C128 Y[3] x3.Z[1] 0.28301f
C129 A[0] Z0[2] 0.21207f
C130 x2.x4.B A[9] 0.10274f
C131 x16.A1 Z1[2] 0.25937f
C132 x4.Z[1] Y[2] 0.10204f
C133 x1.x9.A A[14] 0.15469f
C134 VDD a_2193_n313# 0.2307f
C135 x2.x9.B x2.x9.A 0.35353f
C136 a_2361_n2437# x3.x7.A 0.10994f
C137 x2.x9.B a_2830_n935# 0.1195f
C138 a_2361_n2437# VDD 0.21598f
C139 Y[0] VDD 0.2546f
C140 x16.A1 Z0[2] 0.50619f
C141 x14.X a_1819_n1786# 0.28732f
C142 x2.x7.A A[9] 0.1005f
C143 A[7] A[6] 0.38787f
C144 x4.x8.A a_2361_n3717# 0.116f
C145 Y[3] Z2[2] 0.17883f
C146 x16.A1 Y[2] 0.30765f
C147 x13.X VDD 0.96788f
C148 a_898_345# A[12] 0.1164f
C149 Z0[2] A[12] 0.12327f
C150 a_3281_n3717# Z0[0] 0.11941f
C151 Z3[2] A[12] 0.29081f
C152 Y[3] a_1819_n3066# 0.24814f
C153 A[2] A[1] 1.48313f
C154 A[11] x2.x4.B 0.21158f
C155 VDD a_2073_n1786# 0.12444f
C156 x1.x7.A A[12] 0.15452f
C157 A[14] A[13] 1.48313f
C158 A[3] A[1] 0.18211f
C159 x3.x7.A VDD 0.2996f
C160 Z2[2] a_2193_n313# 0.22034f
C161 VDD a_991_n3066# 0.15333f
C162 x3.Z[1] VDD 1.16933f
C163 A[2] x4.Z[1] 0.5171f
C164 VDD x4.x4.B 0.27742f
C165 VDD x1.x4.B 0.27417f
C166 A[2] A[0] 0.17687f
C167 A[2] x4.x4.A 0.26855f
C168 x16.A0 x13.A0 0.31253f
C169 Y[2] Z0[0] 0.14528f
C170 x2.x7.A A[8] 0.15452f
C171 VDD a_1349_n3717# 0.21785f
C172 x16.A0 x16.X 0.21801f
C173 A[3] A[0] 0.73152f
C174 A[14] A[15] 0.38787f
C175 A[3] x4.x4.A 0.18756f
C176 VDD x3.x9.B 0.27973f
C177 A[14] x13.A0 0.52528f
C178 x4.x4.B a_1349_n3717# 0.22515f
C179 Y[3] a_2073_n3066# 0.32131f
C180 x3.x9.A VDD 1.08756f
C181 x3.x9.A x3.Z[1] 0.24187f
C182 Y[4] VDD 0.25686f
C183 x2.x8.A x2.x9.A 0.16041f
C184 x2.x8.A a_2830_n935# 0.24515f
C185 Y[3] A[6] 0.15592f
C186 a_1245_n1786# Y[2] 0.31893f
C187 Z2[2] VDD 1.47133f
C188 x3.x9.A x3.x9.B 0.35353f
C189 Y[3] A[10] 0.18956f
C190 a_898_n935# A[9] 0.1956f
C191 Z0[2] x8.Y 0.12877f
C192 VDD a_1819_n3066# 0.16031f
C193 A[2] x4.x9.A 0.15469f
C194 x1.x9.A x1.x8.A 0.16041f
C195 x16.X x17.X 0.44178f
C196 Y[3] x14.X 0.13736f
C197 x1.x9.B x1.x9.A 0.35353f
C198 x2.x4.A x2.x4.B 0.38043f
C199 A[2] a_2830_n3495# 0.11164f
C200 VDD a_751_n313# 0.16152f
C201 Y[3] x16.A1 0.11865f
C202 a_1349_n1157# VDD 0.21833f
C203 x13.A1 x13.A0 1.07213f
C204 a_2361_n1157# VDD 0.21563f
C205 x1.x8.A a_2361_123# 0.116f
C206 VDD a_2073_n3066# 0.12746f
C207 A[1] VDD 0.29383f
C208 a_898_n935# A[8] 0.1164f
C209 A[1] x4.x4.B 0.10274f
C210 a_3281_n2437# VDD 0.21446f
C211 A[6] VDD 0.62018f
C212 x10.B a_273_n313# 0.23592f
C213 x3.x8.A a_2830_n2215# 0.24515f
C214 x13.X x14.X 0.39615f
C215 A[6] x3.Z[1] 0.51738f
C216 Y[3] Z0[0] 0.19909f
C217 x4.Z[1] VDD 0.99255f
C218 x4.Z[1] x3.Z[1] 1.67492f
C219 a_2933_n571# Z0[2] 0.22402f
C220 A[10] VDD 0.62248f
C221 A[0] VDD 0.23844f
C222 VDD x4.x4.A 0.87653f
C223 a_2933_n571# Z3[2] 0.24441f
C224 a_3281_n2437# x3.x9.B 0.23074f
C225 x14.X a_2073_n1786# 0.191f
C226 Z1[2] x9.Y 0.18929f
C227 x4.x4.B x4.x4.A 0.38043f
C228 x4.Z[1] a_1349_n3717# 0.11264f
C229 x1.x4.A A[15] 0.18756f
C230 x3.x9.A A[6] 0.15469f
C231 x14.X VDD 0.23221f
C232 a_898_345# A[13] 0.1956f
C233 x16.A1 VDD 0.82228f
C234 A[9] VDD 0.29534f
C235 Z3[2] A[13] 0.19108f
C236 x1.x7.A a_2361_123# 0.10994f
C237 A[7] x3.x4.A 0.18756f
C238 a_2830_345# A[14] 0.11164f
C239 Z1[2] x13.A0 0.35575f
C240 x9.Y Z3[2] 0.11306f
C241 x1.x7.A A[13] 0.1005f
C242 x3.x4.B x3.x4.A 0.38043f
C243 VDD Z1[0] 0.43675f
C244 A[10] Z2[2] 0.42967f
C245 A[12] VDD 0.23681f
C246 a_991_n1786# Y[2] 0.2257f
C247 VDD x4.x9.A 1.08706f
C248 VDD x4.x7.A 0.29836f
C249 Z0[2] x13.A0 0.19606f
C250 Z3[2] A[15] 0.10744f
C251 VDD a_2830_n3495# 0.14679f
C252 Y[2] x13.A0 0.12305f
C253 VDD Z0[0] 1.31477f
C254 a_991_n3066# Z0[0] 0.12019f
C255 Z2[2] A[9] 0.25425f
C256 Z1[2] x6.Y 0.2865f
C257 A[8] VDD 0.24635f
C258 A[11] VDD 0.37134f
C259 a_1193_n313# VDD 0.22238f
C260 x3.x4.B a_1349_n2437# 0.22515f
C261 Z0[2] x6.Y 0.16932f
C262 Y[2] a_417_n3066# 0.35111f
C263 Z3[2] x6.Y 0.33463f
C264 A[0] A[1] 1.03876f
C265 x16.A0 a_3281_123# 0.11772f
C266 A[2] x4.x8.A 0.26778f
C267 A[4] x16.A0 0.31347f
C268 VDD x8.Y 0.27776f
C269 Z2[2] A[8] 0.21212f
C270 A[11] Z2[2] 0.10349f
C271 a_1349_123# x13.A0 0.11264f
C272 x2.x9.B VDD 0.2845f
C273 x13.A1 a_163_n1786# 0.11413f
C274 x16.A1 x4.Z[1] 0.17877f
C275 A[10] A[9] 1.39409f
C276 x1.x8.A a_2830_345# 0.24515f
C277 a_3281_n2437# Z1[0] 0.11851f
C278 x13.A1 x2.x9.A 0.2503f
C279 x1.x8.A A[14] 0.26778f
C280 A[1] x4.x7.A 0.1005f
C281 x1.x9.B a_2830_345# 0.1195f
C282 x1.x4.A A[14] 0.26855f
C283 Y[2] a_1245_n3066# 0.31842f
C284 x2.x4.A VDD 0.87663f
C285 a_273_n313# Z3[2] 0.11619f
C286 x4.Z[1] x4.x9.A 0.24173f
C287 x1.x9.A VDD 1.1009f
C288 a_2361_n1157# A[8] 0.18261f
C289 Y[3] x16.X 0.15603f
C290 A[0] x4.x7.A 0.15452f
C291 a_273_n313# Y[2] 0.11842f
C292 x10.B Z3[2] 0.32897f
C293 x3.x4.A VDD 0.87664f
C294 x4.x9.B a_3281_n3717# 0.23074f
C295 VDD a_898_n3495# 0.16737f
C296 Z0[2] x16.A0 0.11194f
C297 A[4] A[5] 0.95556f
C298 x4.Z[1] Z0[0] 0.2357f
C299 x4.x4.B a_898_n3495# 0.12052f
C300 x16.A1 Z1[0] 0.82392f
C301 a_2933_n571# VDD 0.40022f
C302 x16.A0 Y[2] 0.18252f
C303 Z3[2] A[14] 0.16404f
C304 a_751_n313# x8.Y 0.20087f
C305 a_991_n1786# x13.X 0.1802f
C306 A[11] A[10] 0.38787f
C307 A[10] A[8] 0.17686f
C308 a_2361_123# VDD 0.20958f
C309 a_1245_n1786# x4.Z[1] 0.20442f
C310 A[13] VDD 0.28181f
C311 x2.x8.A VDD 0.19914f
C312 x16.A1 Z0[0] 0.18444f
C313 VDD x4.x8.A 0.19615f
C314 x9.Y VDD 0.43911f
C315 Z1[2] A[5] 0.25395f
C316 a_2933_n571# Y[4] 0.12278f
C317 A[13] x1.x4.B 0.10274f
C318 a_991_n1786# VDD 0.14946f
C319 a_1349_n2437# VDD 0.21857f
C320 A[11] A[9] 0.18211f
C321 A[9] A[8] 0.95556f
C322 Z1[0] Z0[0] 0.65968f
C323 Y[2] a_163_n1786# 0.27791f
C324 a_1349_n2437# x3.Z[1] 0.11295f
C325 a_2193_n313# x6.Y 0.24052f
C326 a_2933_n571# Z2[2] 0.1728f
C327 VDD A[15] 0.35649f
C328 x1.x9.B a_3281_123# 0.23074f
C329 x13.A1 Z1[2] 0.16218f
C330 VDD x13.A0 1.35603f
C331 x3.Z[1] x13.A0 0.11922f
C332 A[15] x1.x4.B 0.21158f
C333 x16.X a_991_n3066# 0.17915f
C334 VDD x16.X 0.28566f
C335 x11.B VDD 0.23958f
C336 A[4] Z1[2] 0.21165f
C337 VDD a_417_n3066# 0.10217f
C338 x13.A1 Y[2] 0.27328f
C339 A[1] a_898_n3495# 0.1956f
C340 A[11] A[8] 0.64595f
C341 VDD x6.Y 0.31128f
C342 x2.x4.A A[10] 0.26854f
C343 A[7] A[5] 0.18211f
C344 Z2[2] x13.A0 0.26459f
C345 x3.x4.B A[5] 0.10274f
C346 A[6] x3.x4.A 0.26854f
C347 a_2361_n2437# x3.x8.A 0.116f
C348 A[0] a_898_n3495# 0.1164f
C349 x2.x8.A a_2361_n1157# 0.116f
C350 A[5] a_898_n2215# 0.1956f
C351 Y[2] a_163_n3066# 0.25902f
C352 A[7] A[4] 0.64595f
C353 Z1[2] Z0[2] 1.87985f
C354 x11.B a_751_n313# 0.13305f
C355 Z2[2] x6.Y 0.27507f
C356 Z1[2] Z3[2] 0.69406f
C357 VDD a_1245_n3066# 0.10144f
C358 x3.x8.A VDD 0.19649f
C359 A[10] x2.x8.A 0.26778f
C360 A[3] GND 1.76887f
C361 A[2] GND 1.11812f
C362 A[1] GND 0.72353f
C363 A[0] GND 1.56342f
C364 Y[0] GND 0.44529f
C365 A[7] GND 1.61538f
C366 A[6] GND 0.91069f
C367 A[5] GND 0.56278f
C368 A[4] GND 1.16755f
C369 Y[1] GND 0.39641f
C370 A[11] GND 1.61704f
C371 A[10] GND 0.90918f
C372 A[9] GND 0.56428f
C373 A[8] GND 1.16601f
C374 Y[4] GND 0.88157f
C375 Y[3] GND 2.21194f
C376 Y[2] GND 5.03954f
C377 A[15] GND 1.77066f
C378 A[14] GND 1.23561f
C379 A[13] GND 0.7427f
C380 A[12] GND 1.32969f
C381 VDD GND 39.56948f
C382 x4.x9.B GND 0.35276f
C383 x4.x8.A GND 0.29703f
C384 x4.x7.A GND 0.28664f
C385 x4.x9.A GND 0.32612f
C386 x4.x4.B GND 0.22332f
C387 x4.x4.A GND 0.26224f
C388 a_3281_n3717# GND 0.22579f
C389 a_2830_n3495# GND 0.20285f
C390 a_2361_n3717# GND 0.21452f
C391 a_1349_n3717# GND 0.20289f
C392 a_898_n3495# GND 0.1925f
C393 a_2073_n3066# GND 0.26081f
C394 x17.X GND 0.25912f
C395 x16.X GND 1.00069f
C396 a_1819_n3066# GND 0.24696f
C397 a_1245_n3066# GND 0.22436f
C398 Z0[0] GND 0.74626f
C399 a_991_n3066# GND 0.24512f
C400 a_417_n3066# GND 0.24291f
C401 a_163_n3066# GND 0.32857f
C402 Z1[0] GND 0.88064f
C403 x3.x9.B GND 0.34532f
C404 x3.x8.A GND 0.29579f
C405 x3.x7.A GND 0.28401f
C406 x3.x9.A GND 0.32587f
C407 x3.x4.B GND 0.22122f
C408 x3.x4.A GND 0.25986f
C409 a_3281_n2437# GND 0.22442f
C410 a_2830_n2215# GND 0.20144f
C411 a_2361_n2437# GND 0.21373f
C412 a_1349_n2437# GND 0.20117f
C413 a_898_n2215# GND 0.19107f
C414 a_2073_n1786# GND 0.25932f
C415 x14.X GND 0.48553f
C416 x13.X GND 0.33526f
C417 a_1819_n1786# GND 0.24853f
C418 a_1245_n1786# GND 0.24433f
C419 x4.Z[1] GND 1.27448f
C420 x3.Z[1] GND 0.59535f
C421 a_991_n1786# GND 0.25942f
C422 a_417_n1786# GND 0.2435f
C423 a_163_n1786# GND 0.32805f
C424 x16.A1 GND 1.36487f
C425 x2.x9.B GND 0.34157f
C426 x2.x8.A GND 0.29279f
C427 x2.x7.A GND 0.28366f
C428 x2.x9.A GND 0.32232f
C429 x13.A1 GND 1.63618f
C430 x2.x4.B GND 0.22125f
C431 x2.x4.A GND 0.26071f
C432 a_3281_n1157# GND 0.22346f
C433 a_2830_n935# GND 0.19565f
C434 a_2361_n1157# GND 0.21246f
C435 a_1349_n1157# GND 0.20143f
C436 a_898_n935# GND 0.19215f
C437 x9.Y GND 0.20098f
C438 x10.B GND 0.27638f
C439 a_2933_n571# GND 0.22619f
C440 Z1[2] GND 1.75259f
C441 x6.Y GND 0.32696f
C442 a_2193_n313# GND 0.21054f
C443 Z2[2] GND 1.7617f
C444 Z0[2] GND 3.07615f
C445 a_1193_n313# GND 0.2216f
C446 x11.B GND 0.28206f
C447 x8.Y GND 0.76591f
C448 a_751_n313# GND 0.19528f
C449 a_273_n313# GND 0.22649f
C450 x16.A0 GND 2.6105f
C451 x1.x9.B GND 0.34771f
C452 x1.x8.A GND 0.29617f
C453 x1.x7.A GND 0.28955f
C454 x1.x9.A GND 0.3418f
C455 x13.A0 GND 1.93194f
C456 x1.x4.B GND 0.22732f
C457 x1.x4.A GND 0.27053f
C458 Z3[2] GND 1.66252f
C459 a_3281_123# GND 0.22534f
C460 a_2830_345# GND 0.20187f
C461 a_2361_123# GND 0.21828f
C462 a_1349_123# GND 0.20955f
C463 a_898_345# GND 0.19819f
C464 VDD.n32 GND 0.22276f
C465 VDD.t2 GND 0.23357f
C466 VDD.t146 GND 0.11224f
C467 VDD.t10 GND 0.10814f
C468 VDD.t160 GND 0.16484f
C469 VDD.t229 GND 0.10405f
C470 VDD.t212 GND 0.13382f
C471 VDD.t222 GND 0.11573f
C472 VDD.t105 GND 0.12779f
C473 VDD.t81 GND 0.10126f
C474 VDD.t256 GND 0.21941f
C475 VDD.t228 GND 0.12417f
C476 VDD.t258 GND 0.11453f
C477 VDD.t213 GND 0.21459f
C478 VDD.t225 GND 0.11694f
C479 VDD.t183 GND 0.11694f
C480 VDD.t110 GND 0.11573f
C481 VDD.t101 GND 0.11573f
C482 VDD.t99 GND 0.19409f
C483 VDD.t158 GND 0.15069f
C484 VDD.t100 GND 0.10126f
C485 VDD.t4 GND 0.12417f
C486 VDD.t189 GND 0.1302f
C487 VDD.t112 GND 0.11453f
C488 VDD.t97 GND 0.16516f
C489 VDD.t254 GND 0.13382f
C490 VDD.t201 GND 0.12176f
C491 VDD.t95 GND 0.19891f
C492 VDD.t15 GND 0.12779f
C493 VDD.t223 GND 0.25798f
C494 VDD.t107 GND 0.20494f
C495 VDD.t203 GND 0.12176f
C496 VDD.t144 GND 0.11453f
C497 VDD.t214 GND 0.16877f
C498 VDD.t142 GND 0.3497f
C499 VDD.n38 GND 0.82647f
C500 VDD.t250 GND 0.13382f
C501 VDD.t236 GND 0.11573f
C502 VDD.t162 GND 0.12779f
C503 VDD.t88 GND 0.10126f
C504 VDD.t230 GND 0.21941f
C505 VDD.t261 GND 0.12417f
C506 VDD.t232 GND 0.11453f
C507 VDD.t251 GND 0.21459f
C508 VDD.t237 GND 0.11694f
C509 VDD.t197 GND 0.11694f
C510 VDD.t169 GND 0.11573f
C511 VDD.t149 GND 0.11573f
C512 VDD.t148 GND 0.19409f
C513 VDD.t128 GND 0.15069f
C514 VDD.t12 GND 0.10126f
C515 VDD.t126 GND 0.12417f
C516 VDD.t191 GND 0.1302f
C517 VDD.t167 GND 0.11453f
C518 VDD.t6 GND 0.16516f
C519 VDD.t234 GND 0.13382f
C520 VDD.t207 GND 0.12176f
C521 VDD.t199 GND 0.19891f
C522 VDD.t166 GND 0.12779f
C523 VDD.t239 GND 0.25798f
C524 VDD.t180 GND 0.20494f
C525 VDD.t205 GND 0.12176f
C526 VDD.t181 GND 0.11453f
C527 VDD.t252 GND 0.16877f
C528 VDD.t124 GND 0.3497f
C529 VDD.t262 GND 0.10405f
C530 VDD.t122 GND 0.16484f
C531 VDD.t118 GND 0.10814f
C532 VDD.t140 GND 0.11224f
C533 VDD.t120 GND 0.23357f
C534 VDD.n53 GND 0.22276f
C535 VDD.t151 GND 0.1099f
C536 VDD.t209 GND 0.11107f
C537 VDD.t241 GND 0.12159f
C538 VDD.t243 GND 0.12334f
C539 VDD.t133 GND 0.10405f
C540 VDD.t18 GND 0.16484f
C541 VDD.t22 GND 0.10814f
C542 VDD.t41 GND 0.11224f
C543 VDD.t16 GND 0.16075f
C544 VDD.t245 GND 0.16134f
C545 VDD.t152 GND 0.16134f
C546 VDD.t36 GND 0.10814f
C547 VDD.t134 GND 0.11224f
C548 VDD.t20 GND 0.16075f
C549 VDD.t211 GND 0.10405f
C550 VDD.t32 GND 0.16484f
C551 VDD.t38 GND 0.10814f
C552 VDD.t48 GND 0.11224f
C553 VDD.t30 GND 0.23357f
C554 VDD.n177 GND 0.22276f
C555 VDD.n353 GND 0.11671f
C556 VDD.n354 GND 0.2996f
C557 VDD.t89 GND 0.12967f
C558 VDD.t24 GND 0.10006f
C559 VDD.t86 GND 0.12055f
C560 VDD.t65 GND 0.12176f
C561 VDD.t53 GND 0.16516f
C562 VDD.t69 GND 0.16154f
C563 VDD.t0 GND 0.1748f
C564 VDD.t91 GND 0.14225f
C565 VDD.t249 GND 0.18806f
C566 VDD.t71 GND 0.14346f
C567 VDD.t55 GND 0.15913f
C568 VDD.t13 GND 0.18806f
C569 VDD.t178 GND 0.1314f
C570 VDD.t26 GND 0.10006f
C571 VDD.t93 GND 0.10126f
C572 VDD.t67 GND 0.12176f
C573 VDD.t59 GND 0.14346f
C574 VDD.t61 GND 0.17601f
C575 VDD.t174 GND 0.18927f
C576 VDD.t63 GND 0.20494f
C577 VDD.t220 GND 0.24593f
C578 VDD.t73 GND 0.20132f
C579 VDD.t156 GND 0.12779f
C580 VDD.t82 GND 0.11091f
C581 VDD.t57 GND 0.10006f
C582 VDD.t84 GND 0.10126f
C583 VDD.t75 GND 0.12176f
C584 VDD.t136 GND 0.22302f
C585 VDD.t79 GND 0.24231f
C586 VDD.t43 GND 0.12779f
C587 VDD.t45 GND 0.16757f
C588 VDD.t216 GND 0.18565f
C589 VDD.t248 GND 0.16395f
C590 VDD.t28 GND 0.14828f
C591 VDD.t218 GND 0.10126f
C592 VDD.t138 GND 0.10126f
C593 VDD.t247 GND 0.1302f
C594 VDD.t77 GND 0.12779f
C595 VDD.t171 GND 0.16395f
C596 VDD.t176 GND 0.15672f
C597 VDD.n392 GND 0.82221f
C598 VDD.n482 GND 1.07528f
C599 VDD.n494 GND 1.07494f
C600 A[12].n0 GND 0.14052f
C601 A[12].n2 GND 0.14518f
C602 A[12].n3 GND 0.16215f
C603 A[12].n4 GND 0.11813f
C604 A[12].n5 GND 0.40654f
C605 A[12].n6 GND 1.72236f
C606 A[13].t1 GND 0.11192f
C607 A[13].n0 GND 0.21042f
C608 A[13].n1 GND 0.23025f
C609 A[13].n2 GND 0.13923f
C610 A[13].n3 GND 0.13389f
C611 A[13].n4 GND 1.84064f
C612 A[13].t5 GND 0.11386f
C613 A[13].n5 GND 0.15932f
C614 A[13].n6 GND 0.31359f
C615 A[14].n0 GND 0.17941f
C616 A[14].n2 GND 0.18668f
C617 A[14].n3 GND 0.8879f
C618 A[14].n4 GND 1.73222f
C619 A[14].n5 GND 0.14988f
C620 A[14].n6 GND 0.20373f
C621 A[15].n0 GND 0.15201f
C622 A[15].n2 GND 0.15261f
C623 A[15].n3 GND 0.1386f
C624 A[15].n4 GND 0.14043f
C625 A[15].n5 GND 0.20366f
C626 A[15].n6 GND 0.96652f
C627 Y[2].n0 GND 0.304f
C628 Y[2].n1 GND 0.12305f
C629 Y[2].n4 GND 0.304f
C630 Y[2].n5 GND 0.12305f
C631 Y[2].n7 GND 0.22071f
C632 Y[2].n8 GND 0.57173f
C633 Y[2].t1 GND 0.12194f
C634 Y[2].n9 GND 0.11414f
C635 Y[2].n10 GND 0.26073f
C636 Y[2].n14 GND 0.304f
C637 Y[2].n15 GND 0.12305f
C638 Y[2].n17 GND 0.2363f
C639 Y[2].n18 GND 0.304f
C640 Y[2].n19 GND 0.12305f
C641 Y[2].n22 GND 0.58073f
C642 Y[2].n23 GND 0.79829f
C643 Y[3].n0 GND 0.35036f
C644 Y[3].n1 GND 0.36472f
C645 Y[3].n2 GND 0.14763f
C646 Y[3].n4 GND 0.89218f
C647 Y[3].t1 GND 0.13639f
C648 Y[3].n5 GND 0.12773f
C649 Y[3].n6 GND 0.16836f
C650 Y[3].n8 GND 0.44574f
C651 Y[3].n9 GND 1.67823f
C652 Y[3].n10 GND 3.30473f
C653 Y[3].n11 GND 0.80124f
C654 Y[3].n12 GND 0.14763f
C655 Y[4].n5 GND 0.1291f
C656 A[8].n0 GND 0.12181f
C657 A[8].n1 GND 0.14971f
C658 A[8].n2 GND 0.16721f
C659 A[8].n3 GND 0.14491f
C660 A[8].n6 GND 1.77606f
C661 A[8].n7 GND 0.41922f
C662 A[9].t1 GND 0.11496f
C663 A[9].n0 GND 0.21612f
C664 A[9].t5 GND 0.11695f
C665 A[9].n1 GND 0.16364f
C666 A[9].n2 GND 0.32209f
C667 A[9].n3 GND 0.143f
C668 A[9].n4 GND 0.13752f
C669 A[9].n5 GND 1.89057f
C670 A[9].n6 GND 0.23649f
C671 A[10].t4 GND 0.10753f
C672 A[10].n0 GND 0.20343f
C673 A[10].t5 GND 0.10943f
C674 A[10].n1 GND 0.16993f
C675 A[10].n2 GND 0.231f
C676 A[10].n3 GND 0.21166f
C677 A[10].n4 GND 1.00673f
C678 A[10].n5 GND 1.96404f
C679 A[11].n0 GND 0.14419f
C680 A[11].n1 GND 0.15607f
C681 A[11].n3 GND 0.15669f
C682 A[11].n4 GND 0.1423f
C683 A[11].n5 GND 0.99235f
C684 A[11].n6 GND 0.2091f
C685 A[4].n0 GND 0.12133f
C686 A[4].n1 GND 0.14912f
C687 A[4].n2 GND 0.16655f
C688 A[4].n3 GND 0.14433f
C689 A[4].n6 GND 1.76903f
C690 A[4].n7 GND 0.41756f
C691 A[5].t1 GND 0.11481f
C692 A[5].n0 GND 0.21584f
C693 A[5].t5 GND 0.1168f
C694 A[5].n1 GND 0.16343f
C695 A[5].n2 GND 0.32167f
C696 A[5].n3 GND 0.14282f
C697 A[5].n4 GND 0.13735f
C698 A[5].n5 GND 1.88812f
C699 A[5].n6 GND 0.23619f
C700 A[6].t4 GND 0.10695f
C701 A[6].n0 GND 0.20234f
C702 A[6].t5 GND 0.10885f
C703 A[6].n1 GND 0.16902f
C704 A[6].n2 GND 0.22976f
C705 A[6].n3 GND 0.21053f
C706 A[6].n4 GND 1.00134f
C707 A[6].n5 GND 1.95352f
C708 A[7].n0 GND 0.14396f
C709 A[7].n1 GND 0.15583f
C710 A[7].n3 GND 0.15644f
C711 A[7].n4 GND 0.14208f
C712 A[7].n5 GND 0.99081f
C713 A[7].n6 GND 0.20877f
C714 A[0].n0 GND 0.12839f
C715 A[0].n2 GND 0.13265f
C716 A[0].n3 GND 0.14816f
C717 A[0].n4 GND 0.10793f
C718 A[0].n5 GND 0.37145f
C719 A[0].n6 GND 1.57368f
C720 A[1].t1 GND 0.1145f
C721 A[1].n0 GND 0.21527f
C722 A[1].n1 GND 0.23555f
C723 A[1].n2 GND 0.14243f
C724 A[1].n3 GND 0.13698f
C725 A[1].n4 GND 1.88307f
C726 A[1].t5 GND 0.11649f
C727 A[1].n5 GND 0.16299f
C728 A[1].n6 GND 0.32082f
C729 A[2].t4 GND 0.10432f
C730 A[2].n0 GND 0.19735f
C731 A[2].n2 GND 0.20534f
C732 A[2].n3 GND 0.97668f
C733 A[2].n4 GND 1.90542f
C734 A[2].t5 GND 0.10617f
C735 A[2].n5 GND 0.16486f
C736 A[2].n6 GND 0.2241f
C737 A[3].n0 GND 0.15154f
C738 A[3].n2 GND 0.15213f
C739 A[3].n3 GND 0.13817f
C740 A[3].n4 GND 0.14f
C741 A[3].n5 GND 0.20302f
C742 A[3].n6 GND 0.96353f
.ends
